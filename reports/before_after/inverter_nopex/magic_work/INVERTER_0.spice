* NGSPICE file created from INVERTER_0.ext - technology: sky130A

.subckt NMOS_S_10961373_X5_Y2_1782175707_1782175707 a_200_252# a_402_462# a_147_462#
X0 a_832_1638# a_200_252# a_746_1638# a_147_462# sky130_fd_pr__nfet_01v8_lvt ad=0.147 pd=1.33 as=0.147 ps=1.33 w=1.05 l=0.15
X1 a_402_462# a_200_252# a_1348_1638# a_147_462# sky130_fd_pr__nfet_01v8_lvt ad=0.147 pd=1.33 as=0.147 ps=1.33 w=1.05 l=0.15
X2 a_1520_462# a_200_252# a_402_462# a_147_462# sky130_fd_pr__nfet_01v8_lvt ad=0.147 pd=1.33 as=0.147 ps=1.33 w=1.05 l=0.15
X3 a_316_1638# a_200_252# a_230_1638# a_147_462# sky130_fd_pr__nfet_01v8_lvt ad=0.147 pd=1.33 as=0.147 ps=1.33 w=1.05 l=0.15
X4 a_574_1638# a_200_252# a_488_1638# a_147_462# sky130_fd_pr__nfet_01v8_lvt ad=0.147 pd=1.33 as=0.147 ps=1.33 w=1.05 l=0.15
X5 a_147_462# a_200_252# a_1090_1638# a_147_462# sky130_fd_pr__nfet_01v8_lvt ad=0.147 pd=1.33 as=0.147 ps=1.33 w=1.05 l=0.15
X6 a_402_462# a_200_252# a_1348_462# a_147_462# sky130_fd_pr__nfet_01v8_lvt ad=0.147 pd=1.33 as=0.147 ps=1.33 w=1.05 l=0.15
X7 a_402_462# a_200_252# a_832_1638# a_147_462# sky130_fd_pr__nfet_01v8_lvt ad=0.147 pd=1.33 as=0.147 ps=1.33 w=1.05 l=0.15
X8 a_1778_1638# a_200_252# a_147_462# a_147_462# sky130_fd_pr__nfet_01v8_lvt ad=0.147 pd=1.33 as=0.147 ps=1.33 w=1.05 l=0.15
X9 a_1864_462# a_200_252# a_1778_462# a_147_462# sky130_fd_pr__nfet_01v8_lvt ad=0.147 pd=1.33 as=0.147 ps=1.33 w=1.05 l=0.15
X10 a_147_462# a_200_252# a_574_1638# a_147_462# sky130_fd_pr__nfet_01v8_lvt ad=0.147 pd=1.33 as=0.147 ps=1.33 w=1.05 l=0.15
X11 a_1262_1638# a_200_252# a_147_462# a_147_462# sky130_fd_pr__nfet_01v8_lvt ad=0.147 pd=1.33 as=0.147 ps=1.33 w=1.05 l=0.15
X12 a_402_462# a_200_252# a_316_462# a_147_462# sky130_fd_pr__nfet_01v8_lvt ad=0.147 pd=1.33 as=0.147 ps=1.33 w=1.05 l=0.15
X13 a_2380_462# a_200_252# a_2294_462# a_147_462# sky130_fd_pr__nfet_01v8_lvt ad=0.147 pd=1.33 as=0.147 ps=1.33 w=1.05 l=0.15
X14 a_402_462# a_200_252# a_316_1638# a_147_462# sky130_fd_pr__nfet_01v8_lvt ad=0.147 pd=1.33 as=0.147 ps=1.33 w=1.05 l=0.15
X15 a_1864_1638# a_200_252# a_1778_1638# a_147_462# sky130_fd_pr__nfet_01v8_lvt ad=0.147 pd=1.33 as=0.147 ps=1.33 w=1.05 l=0.15
X16 a_746_462# a_200_252# a_147_462# a_147_462# sky130_fd_pr__nfet_01v8_lvt ad=0.147 pd=1.33 as=0.147 ps=1.33 w=1.05 l=0.15
X17 a_1004_1638# a_200_252# a_402_462# a_147_462# sky130_fd_pr__nfet_01v8_lvt ad=0.147 pd=1.33 as=0.147 ps=1.33 w=1.05 l=0.15
X18 a_1606_1638# a_200_252# a_1520_1638# a_147_462# sky130_fd_pr__nfet_01v8_lvt ad=0.147 pd=1.33 as=0.147 ps=1.33 w=1.05 l=0.15
X19 a_1090_1638# a_200_252# a_1004_1638# a_147_462# sky130_fd_pr__nfet_01v8_lvt ad=0.147 pd=1.33 as=0.147 ps=1.33 w=1.05 l=0.15
X20 a_402_462# a_200_252# a_1864_1638# a_147_462# sky130_fd_pr__nfet_01v8_lvt ad=0.147 pd=1.33 as=0.147 ps=1.33 w=1.05 l=0.15
X21 a_147_462# a_200_252# a_1606_1638# a_147_462# sky130_fd_pr__nfet_01v8_lvt ad=0.147 pd=1.33 as=0.147 ps=1.33 w=1.05 l=0.15
X22 a_147_462# a_200_252# a_1090_462# a_147_462# sky130_fd_pr__nfet_01v8_lvt ad=0.147 pd=1.33 as=0.147 ps=1.33 w=1.05 l=0.15
X23 a_1606_462# a_200_252# a_1520_462# a_147_462# sky130_fd_pr__nfet_01v8_lvt ad=0.147 pd=1.33 as=0.147 ps=1.33 w=1.05 l=0.15
X24 a_402_462# a_200_252# a_1864_462# a_147_462# sky130_fd_pr__nfet_01v8_lvt ad=0.147 pd=1.33 as=0.147 ps=1.33 w=1.05 l=0.15
X25 a_2122_462# a_200_252# a_2036_462# a_147_462# sky130_fd_pr__nfet_01v8_lvt ad=0.147 pd=1.33 as=0.147 ps=1.33 w=1.05 l=0.15
X26 a_1520_1638# a_200_252# a_402_462# a_147_462# sky130_fd_pr__nfet_01v8_lvt ad=0.147 pd=1.33 as=0.147 ps=1.33 w=1.05 l=0.15
X27 a_2036_462# a_200_252# a_402_462# a_147_462# sky130_fd_pr__nfet_01v8_lvt ad=0.147 pd=1.33 as=0.147 ps=1.33 w=1.05 l=0.15
X28 a_2036_1638# a_200_252# a_402_462# a_147_462# sky130_fd_pr__nfet_01v8_lvt ad=0.147 pd=1.33 as=0.147 ps=1.33 w=1.05 l=0.15
X29 a_488_462# a_200_252# a_402_462# a_147_462# sky130_fd_pr__nfet_01v8_lvt ad=0.147 pd=1.33 as=0.147 ps=1.33 w=1.05 l=0.15
X30 a_832_462# a_200_252# a_746_462# a_147_462# sky130_fd_pr__nfet_01v8_lvt ad=0.147 pd=1.33 as=0.147 ps=1.33 w=1.05 l=0.15
X31 a_402_462# a_200_252# a_2380_462# a_147_462# sky130_fd_pr__nfet_01v8_lvt ad=0.147 pd=1.33 as=0.147 ps=1.33 w=1.05 l=0.15
X32 a_2638_1638# a_200_252# a_2552_1638# a_147_462# sky130_fd_pr__nfet_01v8_lvt ad=0.147 pd=1.33 as=0.147 ps=1.33 w=1.05 l=0.15
X33 a_402_462# a_200_252# a_832_462# a_147_462# sky130_fd_pr__nfet_01v8_lvt ad=0.147 pd=1.33 as=0.147 ps=1.33 w=1.05 l=0.15
X34 a_402_462# a_200_252# a_2380_1638# a_147_462# sky130_fd_pr__nfet_01v8_lvt ad=0.147 pd=1.33 as=0.147 ps=1.33 w=1.05 l=0.15
X35 a_1262_462# a_200_252# a_147_462# a_147_462# sky130_fd_pr__nfet_01v8_lvt ad=0.147 pd=1.33 as=0.147 ps=1.33 w=1.05 l=0.15
X36 a_147_462# a_200_252# a_2122_1638# a_147_462# sky130_fd_pr__nfet_01v8_lvt ad=0.147 pd=1.33 as=0.147 ps=1.33 w=1.05 l=0.15
X37 a_147_462# a_200_252# a_1606_462# a_147_462# sky130_fd_pr__nfet_01v8_lvt ad=0.147 pd=1.33 as=0.147 ps=1.33 w=1.05 l=0.15
X38 a_2294_1638# a_200_252# a_147_462# a_147_462# sky130_fd_pr__nfet_01v8_lvt ad=0.147 pd=1.33 as=0.147 ps=1.33 w=1.05 l=0.15
X39 a_2552_1638# a_200_252# a_402_462# a_147_462# sky130_fd_pr__nfet_01v8_lvt ad=0.147 pd=1.33 as=0.147 ps=1.33 w=1.05 l=0.15
X40 a_574_462# a_200_252# a_488_462# a_147_462# sky130_fd_pr__nfet_01v8_lvt ad=0.147 pd=1.33 as=0.147 ps=1.33 w=1.05 l=0.15
X41 a_147_462# a_200_252# a_2122_462# a_147_462# sky130_fd_pr__nfet_01v8_lvt ad=0.147 pd=1.33 as=0.147 ps=1.33 w=1.05 l=0.15
X42 a_2552_462# a_200_252# a_402_462# a_147_462# sky130_fd_pr__nfet_01v8_lvt ad=0.147 pd=1.33 as=0.147 ps=1.33 w=1.05 l=0.15
X43 a_1004_462# a_200_252# a_402_462# a_147_462# sky130_fd_pr__nfet_01v8_lvt ad=0.147 pd=1.33 as=0.147 ps=1.33 w=1.05 l=0.15
X44 a_2380_1638# a_200_252# a_2294_1638# a_147_462# sky130_fd_pr__nfet_01v8_lvt ad=0.147 pd=1.33 as=0.147 ps=1.33 w=1.05 l=0.15
X45 a_2122_1638# a_200_252# a_2036_1638# a_147_462# sky130_fd_pr__nfet_01v8_lvt ad=0.147 pd=1.33 as=0.147 ps=1.33 w=1.05 l=0.15
X46 a_147_462# a_200_252# a_2638_1638# a_147_462# sky130_fd_pr__nfet_01v8_lvt ad=0.27825 pd=2.63 as=0.147 ps=1.33 w=1.05 l=0.15
X47 a_1348_462# a_200_252# a_1262_462# a_147_462# sky130_fd_pr__nfet_01v8_lvt ad=0.147 pd=1.33 as=0.147 ps=1.33 w=1.05 l=0.15
X48 a_230_462# a_200_252# a_147_462# a_147_462# sky130_fd_pr__nfet_01v8_lvt ad=0.147 pd=1.33 as=0.27825 ps=2.63 w=1.05 l=0.15
X49 a_1778_462# a_200_252# a_147_462# a_147_462# sky130_fd_pr__nfet_01v8_lvt ad=0.147 pd=1.33 as=0.147 ps=1.33 w=1.05 l=0.15
X50 a_316_462# a_200_252# a_230_462# a_147_462# sky130_fd_pr__nfet_01v8_lvt ad=0.147 pd=1.33 as=0.147 ps=1.33 w=1.05 l=0.15
X51 a_147_462# a_200_252# a_574_462# a_147_462# sky130_fd_pr__nfet_01v8_lvt ad=0.147 pd=1.33 as=0.147 ps=1.33 w=1.05 l=0.15
X52 a_2294_462# a_200_252# a_147_462# a_147_462# sky130_fd_pr__nfet_01v8_lvt ad=0.147 pd=1.33 as=0.147 ps=1.33 w=1.05 l=0.15
X53 a_147_462# a_200_252# a_2638_462# a_147_462# sky130_fd_pr__nfet_01v8_lvt ad=0.27825 pd=2.63 as=0.147 ps=1.33 w=1.05 l=0.15
X54 a_2638_462# a_200_252# a_2552_462# a_147_462# sky130_fd_pr__nfet_01v8_lvt ad=0.147 pd=1.33 as=0.147 ps=1.33 w=1.05 l=0.15
X55 a_488_1638# a_200_252# a_402_462# a_147_462# sky130_fd_pr__nfet_01v8_lvt ad=0.147 pd=1.33 as=0.147 ps=1.33 w=1.05 l=0.15
X56 a_746_1638# a_200_252# a_147_462# a_147_462# sky130_fd_pr__nfet_01v8_lvt ad=0.147 pd=1.33 as=0.147 ps=1.33 w=1.05 l=0.15
X57 a_1348_1638# a_200_252# a_1262_1638# a_147_462# sky130_fd_pr__nfet_01v8_lvt ad=0.147 pd=1.33 as=0.147 ps=1.33 w=1.05 l=0.15
X58 a_230_1638# a_200_252# a_147_462# a_147_462# sky130_fd_pr__nfet_01v8_lvt ad=0.147 pd=1.33 as=0.27825 ps=2.63 w=1.05 l=0.15
X59 a_1090_462# a_200_252# a_1004_462# a_147_462# sky130_fd_pr__nfet_01v8_lvt ad=0.147 pd=1.33 as=0.147 ps=1.33 w=1.05 l=0.15
.ends

.subckt PMOS_S_70655723_X5_Y2_1782175708_1782175707 a_200_252# a_402_462# w_0_0# VSUBS
X0 a_402_462# a_200_252# a_316_1638# w_0_0# sky130_fd_pr__pfet_01v8_lvt ad=0.147 pd=1.33 as=0.147 ps=1.33 w=1.05 l=0.15
X1 w_0_0# a_200_252# a_574_1638# w_0_0# sky130_fd_pr__pfet_01v8_lvt ad=0.147 pd=1.33 as=0.147 ps=1.33 w=1.05 l=0.15
X2 a_1262_1638# a_200_252# w_0_0# w_0_0# sky130_fd_pr__pfet_01v8_lvt ad=0.147 pd=1.33 as=0.147 ps=1.33 w=1.05 l=0.15
X3 a_1004_1638# a_200_252# a_402_462# w_0_0# sky130_fd_pr__pfet_01v8_lvt ad=0.147 pd=1.33 as=0.147 ps=1.33 w=1.05 l=0.15
X4 a_1864_1638# a_200_252# a_1778_1638# w_0_0# sky130_fd_pr__pfet_01v8_lvt ad=0.147 pd=1.33 as=0.147 ps=1.33 w=1.05 l=0.15
X5 a_746_462# a_200_252# w_0_0# w_0_0# sky130_fd_pr__pfet_01v8_lvt ad=0.147 pd=1.33 as=0.147 ps=1.33 w=1.05 l=0.15
X6 a_1606_1638# a_200_252# a_1520_1638# w_0_0# sky130_fd_pr__pfet_01v8_lvt ad=0.147 pd=1.33 as=0.147 ps=1.33 w=1.05 l=0.15
X7 a_1090_1638# a_200_252# a_1004_1638# w_0_0# sky130_fd_pr__pfet_01v8_lvt ad=0.147 pd=1.33 as=0.147 ps=1.33 w=1.05 l=0.15
X8 a_402_462# a_200_252# a_1864_1638# w_0_0# sky130_fd_pr__pfet_01v8_lvt ad=0.147 pd=1.33 as=0.147 ps=1.33 w=1.05 l=0.15
X9 w_0_0# a_200_252# a_1606_1638# w_0_0# sky130_fd_pr__pfet_01v8_lvt ad=0.147 pd=1.33 as=0.147 ps=1.33 w=1.05 l=0.15
X10 w_0_0# a_200_252# a_1090_462# w_0_0# sky130_fd_pr__pfet_01v8_lvt ad=0.147 pd=1.33 as=0.147 ps=1.33 w=1.05 l=0.15
X11 a_1606_462# a_200_252# a_1520_462# w_0_0# sky130_fd_pr__pfet_01v8_lvt ad=0.147 pd=1.33 as=0.147 ps=1.33 w=1.05 l=0.15
X12 a_402_462# a_200_252# a_1864_462# w_0_0# sky130_fd_pr__pfet_01v8_lvt ad=0.147 pd=1.33 as=0.147 ps=1.33 w=1.05 l=0.15
X13 a_1520_1638# a_200_252# a_402_462# w_0_0# sky130_fd_pr__pfet_01v8_lvt ad=0.147 pd=1.33 as=0.147 ps=1.33 w=1.05 l=0.15
X14 a_2036_462# a_200_252# a_402_462# w_0_0# sky130_fd_pr__pfet_01v8_lvt ad=0.147 pd=1.33 as=0.147 ps=1.33 w=1.05 l=0.15
X15 a_2122_462# a_200_252# a_2036_462# w_0_0# sky130_fd_pr__pfet_01v8_lvt ad=0.147 pd=1.33 as=0.147 ps=1.33 w=1.05 l=0.15
X16 a_488_462# a_200_252# a_402_462# w_0_0# sky130_fd_pr__pfet_01v8_lvt ad=0.147 pd=1.33 as=0.147 ps=1.33 w=1.05 l=0.15
X17 a_832_462# a_200_252# a_746_462# w_0_0# sky130_fd_pr__pfet_01v8_lvt ad=0.147 pd=1.33 as=0.147 ps=1.33 w=1.05 l=0.15
X18 a_402_462# a_200_252# a_2380_462# w_0_0# sky130_fd_pr__pfet_01v8_lvt ad=0.147 pd=1.33 as=0.147 ps=1.33 w=1.05 l=0.15
X19 a_2036_1638# a_200_252# a_402_462# w_0_0# sky130_fd_pr__pfet_01v8_lvt ad=0.147 pd=1.33 as=0.147 ps=1.33 w=1.05 l=0.15
X20 a_2638_1638# a_200_252# a_2552_1638# w_0_0# sky130_fd_pr__pfet_01v8_lvt ad=0.147 pd=1.33 as=0.147 ps=1.33 w=1.05 l=0.15
X21 a_402_462# a_200_252# a_832_462# w_0_0# sky130_fd_pr__pfet_01v8_lvt ad=0.147 pd=1.33 as=0.147 ps=1.33 w=1.05 l=0.15
X22 a_1262_462# a_200_252# w_0_0# w_0_0# sky130_fd_pr__pfet_01v8_lvt ad=0.147 pd=1.33 as=0.147 ps=1.33 w=1.05 l=0.15
X23 w_0_0# a_200_252# a_2122_1638# w_0_0# sky130_fd_pr__pfet_01v8_lvt ad=0.147 pd=1.33 as=0.147 ps=1.33 w=1.05 l=0.15
X24 a_402_462# a_200_252# a_2380_1638# w_0_0# sky130_fd_pr__pfet_01v8_lvt ad=0.147 pd=1.33 as=0.147 ps=1.33 w=1.05 l=0.15
X25 w_0_0# a_200_252# a_1606_462# w_0_0# sky130_fd_pr__pfet_01v8_lvt ad=0.147 pd=1.33 as=0.147 ps=1.33 w=1.05 l=0.15
X26 a_2552_1638# a_200_252# a_402_462# w_0_0# sky130_fd_pr__pfet_01v8_lvt ad=0.147 pd=1.33 as=0.147 ps=1.33 w=1.05 l=0.15
X27 a_2294_1638# a_200_252# w_0_0# w_0_0# sky130_fd_pr__pfet_01v8_lvt ad=0.147 pd=1.33 as=0.147 ps=1.33 w=1.05 l=0.15
X28 a_574_462# a_200_252# a_488_462# w_0_0# sky130_fd_pr__pfet_01v8_lvt ad=0.147 pd=1.33 as=0.147 ps=1.33 w=1.05 l=0.15
X29 w_0_0# a_200_252# a_2122_462# w_0_0# sky130_fd_pr__pfet_01v8_lvt ad=0.147 pd=1.33 as=0.147 ps=1.33 w=1.05 l=0.15
X30 a_2552_462# a_200_252# a_402_462# w_0_0# sky130_fd_pr__pfet_01v8_lvt ad=0.147 pd=1.33 as=0.147 ps=1.33 w=1.05 l=0.15
X31 a_1004_462# a_200_252# a_402_462# w_0_0# sky130_fd_pr__pfet_01v8_lvt ad=0.147 pd=1.33 as=0.147 ps=1.33 w=1.05 l=0.15
X32 a_2380_1638# a_200_252# a_2294_1638# w_0_0# sky130_fd_pr__pfet_01v8_lvt ad=0.147 pd=1.33 as=0.147 ps=1.33 w=1.05 l=0.15
X33 a_2122_1638# a_200_252# a_2036_1638# w_0_0# sky130_fd_pr__pfet_01v8_lvt ad=0.147 pd=1.33 as=0.147 ps=1.33 w=1.05 l=0.15
X34 w_0_0# a_200_252# a_2638_1638# w_0_0# sky130_fd_pr__pfet_01v8_lvt ad=0.27825 pd=2.63 as=0.147 ps=1.33 w=1.05 l=0.15
X35 a_1348_462# a_200_252# a_1262_462# w_0_0# sky130_fd_pr__pfet_01v8_lvt ad=0.147 pd=1.33 as=0.147 ps=1.33 w=1.05 l=0.15
X36 a_230_462# a_200_252# w_0_0# w_0_0# sky130_fd_pr__pfet_01v8_lvt ad=0.147 pd=1.33 as=0.27825 ps=2.63 w=1.05 l=0.15
X37 a_316_462# a_200_252# a_230_462# w_0_0# sky130_fd_pr__pfet_01v8_lvt ad=0.147 pd=1.33 as=0.147 ps=1.33 w=1.05 l=0.15
X38 a_1778_462# a_200_252# w_0_0# w_0_0# sky130_fd_pr__pfet_01v8_lvt ad=0.147 pd=1.33 as=0.147 ps=1.33 w=1.05 l=0.15
X39 a_2294_462# a_200_252# w_0_0# w_0_0# sky130_fd_pr__pfet_01v8_lvt ad=0.147 pd=1.33 as=0.147 ps=1.33 w=1.05 l=0.15
X40 w_0_0# a_200_252# a_574_462# w_0_0# sky130_fd_pr__pfet_01v8_lvt ad=0.147 pd=1.33 as=0.147 ps=1.33 w=1.05 l=0.15
X41 a_2638_462# a_200_252# a_2552_462# w_0_0# sky130_fd_pr__pfet_01v8_lvt ad=0.147 pd=1.33 as=0.147 ps=1.33 w=1.05 l=0.15
X42 w_0_0# a_200_252# a_2638_462# w_0_0# sky130_fd_pr__pfet_01v8_lvt ad=0.27825 pd=2.63 as=0.147 ps=1.33 w=1.05 l=0.15
X43 a_746_1638# a_200_252# w_0_0# w_0_0# sky130_fd_pr__pfet_01v8_lvt ad=0.147 pd=1.33 as=0.147 ps=1.33 w=1.05 l=0.15
X44 a_1348_1638# a_200_252# a_1262_1638# w_0_0# sky130_fd_pr__pfet_01v8_lvt ad=0.147 pd=1.33 as=0.147 ps=1.33 w=1.05 l=0.15
X45 a_488_1638# a_200_252# a_402_462# w_0_0# sky130_fd_pr__pfet_01v8_lvt ad=0.147 pd=1.33 as=0.147 ps=1.33 w=1.05 l=0.15
X46 a_1090_462# a_200_252# a_1004_462# w_0_0# sky130_fd_pr__pfet_01v8_lvt ad=0.147 pd=1.33 as=0.147 ps=1.33 w=1.05 l=0.15
X47 a_230_1638# a_200_252# w_0_0# w_0_0# sky130_fd_pr__pfet_01v8_lvt ad=0.147 pd=1.33 as=0.27825 ps=2.63 w=1.05 l=0.15
X48 a_574_1638# a_200_252# a_488_1638# w_0_0# sky130_fd_pr__pfet_01v8_lvt ad=0.147 pd=1.33 as=0.147 ps=1.33 w=1.05 l=0.15
X49 a_832_1638# a_200_252# a_746_1638# w_0_0# sky130_fd_pr__pfet_01v8_lvt ad=0.147 pd=1.33 as=0.147 ps=1.33 w=1.05 l=0.15
X50 w_0_0# a_200_252# a_1090_1638# w_0_0# sky130_fd_pr__pfet_01v8_lvt ad=0.147 pd=1.33 as=0.147 ps=1.33 w=1.05 l=0.15
X51 a_402_462# a_200_252# a_1348_1638# w_0_0# sky130_fd_pr__pfet_01v8_lvt ad=0.147 pd=1.33 as=0.147 ps=1.33 w=1.05 l=0.15
X52 a_402_462# a_200_252# a_1348_462# w_0_0# sky130_fd_pr__pfet_01v8_lvt ad=0.147 pd=1.33 as=0.147 ps=1.33 w=1.05 l=0.15
X53 a_1520_462# a_200_252# a_402_462# w_0_0# sky130_fd_pr__pfet_01v8_lvt ad=0.147 pd=1.33 as=0.147 ps=1.33 w=1.05 l=0.15
X54 a_316_1638# a_200_252# a_230_1638# w_0_0# sky130_fd_pr__pfet_01v8_lvt ad=0.147 pd=1.33 as=0.147 ps=1.33 w=1.05 l=0.15
X55 a_1778_1638# a_200_252# w_0_0# w_0_0# sky130_fd_pr__pfet_01v8_lvt ad=0.147 pd=1.33 as=0.147 ps=1.33 w=1.05 l=0.15
X56 a_1864_462# a_200_252# a_1778_462# w_0_0# sky130_fd_pr__pfet_01v8_lvt ad=0.147 pd=1.33 as=0.147 ps=1.33 w=1.05 l=0.15
X57 a_402_462# a_200_252# a_832_1638# w_0_0# sky130_fd_pr__pfet_01v8_lvt ad=0.147 pd=1.33 as=0.147 ps=1.33 w=1.05 l=0.15
X58 a_402_462# a_200_252# a_316_462# w_0_0# sky130_fd_pr__pfet_01v8_lvt ad=0.147 pd=1.33 as=0.147 ps=1.33 w=1.05 l=0.15
X59 a_2380_462# a_200_252# a_2294_462# w_0_0# sky130_fd_pr__pfet_01v8_lvt ad=0.147 pd=1.33 as=0.147 ps=1.33 w=1.05 l=0.15
.ends

.subckt INV_3799024_0_0_1782175707 m2_1434_1764# m2_1348_2604# PMOS_S_70655723_X5_Y2_1782175708_1782175707_0/w_0_0#
+ VSUBS
XNMOS_S_10961373_X5_Y2_1782175707_1782175707_0 m2_1434_1764# m2_1348_2604# VSUBS NMOS_S_10961373_X5_Y2_1782175707_1782175707
XPMOS_S_70655723_X5_Y2_1782175708_1782175707_0 m2_1434_1764# m2_1348_2604# PMOS_S_70655723_X5_Y2_1782175708_1782175707_0/w_0_0#
+ VSUBS PMOS_S_70655723_X5_Y2_1782175708_1782175707
.ends

.subckt INVERTER_0
XINV_3799024_0_0_1782175707_0 IN OUT VDD VSS INV_3799024_0_0_1782175707
.ends
