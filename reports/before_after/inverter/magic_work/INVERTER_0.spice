* NGSPICE file created from INVERTER_0.ext - technology: sky130A

.subckt NMOS_S_10961373_X5_Y2_1782175707_1782175707 a_200_252# a_402_462# a_147_462#
X0 a_832_1638# a_200_252# a_746_1638# a_147_462# sky130_fd_pr__nfet_01v8_lvt ad=0.147 pd=1.33 as=0.147 ps=1.33 w=1.05 l=0.15
X1 a_402_462# a_200_252# a_1348_1638# a_147_462# sky130_fd_pr__nfet_01v8_lvt ad=0.147 pd=1.33 as=0.147 ps=1.33 w=1.05 l=0.15
X2 a_1520_462# a_200_252# a_402_462# a_147_462# sky130_fd_pr__nfet_01v8_lvt ad=0.147 pd=1.33 as=0.147 ps=1.33 w=1.05 l=0.15
X3 a_316_1638# a_200_252# a_230_1638# a_147_462# sky130_fd_pr__nfet_01v8_lvt ad=0.147 pd=1.33 as=0.147 ps=1.33 w=1.05 l=0.15
X4 a_574_1638# a_200_252# a_488_1638# a_147_462# sky130_fd_pr__nfet_01v8_lvt ad=0.147 pd=1.33 as=0.147 ps=1.33 w=1.05 l=0.15
X5 a_147_462# a_200_252# a_1090_1638# a_147_462# sky130_fd_pr__nfet_01v8_lvt ad=0.147 pd=1.33 as=0.147 ps=1.33 w=1.05 l=0.15
X6 a_402_462# a_200_252# a_1348_462# a_147_462# sky130_fd_pr__nfet_01v8_lvt ad=0.147 pd=1.33 as=0.147 ps=1.33 w=1.05 l=0.15
X7 a_402_462# a_200_252# a_832_1638# a_147_462# sky130_fd_pr__nfet_01v8_lvt ad=0.147 pd=1.33 as=0.147 ps=1.33 w=1.05 l=0.15
X8 a_1778_1638# a_200_252# a_147_462# a_147_462# sky130_fd_pr__nfet_01v8_lvt ad=0.147 pd=1.33 as=0.147 ps=1.33 w=1.05 l=0.15
X9 a_1864_462# a_200_252# a_1778_462# a_147_462# sky130_fd_pr__nfet_01v8_lvt ad=0.147 pd=1.33 as=0.147 ps=1.33 w=1.05 l=0.15
X10 a_147_462# a_200_252# a_574_1638# a_147_462# sky130_fd_pr__nfet_01v8_lvt ad=0.147 pd=1.33 as=0.147 ps=1.33 w=1.05 l=0.15
X11 a_1262_1638# a_200_252# a_147_462# a_147_462# sky130_fd_pr__nfet_01v8_lvt ad=0.147 pd=1.33 as=0.147 ps=1.33 w=1.05 l=0.15
X12 a_402_462# a_200_252# a_316_462# a_147_462# sky130_fd_pr__nfet_01v8_lvt ad=0.147 pd=1.33 as=0.147 ps=1.33 w=1.05 l=0.15
X13 a_2380_462# a_200_252# a_2294_462# a_147_462# sky130_fd_pr__nfet_01v8_lvt ad=0.147 pd=1.33 as=0.147 ps=1.33 w=1.05 l=0.15
X14 a_402_462# a_200_252# a_316_1638# a_147_462# sky130_fd_pr__nfet_01v8_lvt ad=0.147 pd=1.33 as=0.147 ps=1.33 w=1.05 l=0.15
X15 a_1864_1638# a_200_252# a_1778_1638# a_147_462# sky130_fd_pr__nfet_01v8_lvt ad=0.147 pd=1.33 as=0.147 ps=1.33 w=1.05 l=0.15
X16 a_746_462# a_200_252# a_147_462# a_147_462# sky130_fd_pr__nfet_01v8_lvt ad=0.147 pd=1.33 as=0.147 ps=1.33 w=1.05 l=0.15
X17 a_1004_1638# a_200_252# a_402_462# a_147_462# sky130_fd_pr__nfet_01v8_lvt ad=0.147 pd=1.33 as=0.147 ps=1.33 w=1.05 l=0.15
X18 a_1606_1638# a_200_252# a_1520_1638# a_147_462# sky130_fd_pr__nfet_01v8_lvt ad=0.147 pd=1.33 as=0.147 ps=1.33 w=1.05 l=0.15
X19 a_1090_1638# a_200_252# a_1004_1638# a_147_462# sky130_fd_pr__nfet_01v8_lvt ad=0.147 pd=1.33 as=0.147 ps=1.33 w=1.05 l=0.15
X20 a_402_462# a_200_252# a_1864_1638# a_147_462# sky130_fd_pr__nfet_01v8_lvt ad=0.147 pd=1.33 as=0.147 ps=1.33 w=1.05 l=0.15
X21 a_147_462# a_200_252# a_1606_1638# a_147_462# sky130_fd_pr__nfet_01v8_lvt ad=0.147 pd=1.33 as=0.147 ps=1.33 w=1.05 l=0.15
X22 a_147_462# a_200_252# a_1090_462# a_147_462# sky130_fd_pr__nfet_01v8_lvt ad=0.147 pd=1.33 as=0.147 ps=1.33 w=1.05 l=0.15
X23 a_1606_462# a_200_252# a_1520_462# a_147_462# sky130_fd_pr__nfet_01v8_lvt ad=0.147 pd=1.33 as=0.147 ps=1.33 w=1.05 l=0.15
X24 a_402_462# a_200_252# a_1864_462# a_147_462# sky130_fd_pr__nfet_01v8_lvt ad=0.147 pd=1.33 as=0.147 ps=1.33 w=1.05 l=0.15
X25 a_2122_462# a_200_252# a_2036_462# a_147_462# sky130_fd_pr__nfet_01v8_lvt ad=0.147 pd=1.33 as=0.147 ps=1.33 w=1.05 l=0.15
X26 a_1520_1638# a_200_252# a_402_462# a_147_462# sky130_fd_pr__nfet_01v8_lvt ad=0.147 pd=1.33 as=0.147 ps=1.33 w=1.05 l=0.15
X27 a_2036_462# a_200_252# a_402_462# a_147_462# sky130_fd_pr__nfet_01v8_lvt ad=0.147 pd=1.33 as=0.147 ps=1.33 w=1.05 l=0.15
X28 a_2036_1638# a_200_252# a_402_462# a_147_462# sky130_fd_pr__nfet_01v8_lvt ad=0.147 pd=1.33 as=0.147 ps=1.33 w=1.05 l=0.15
X29 a_488_462# a_200_252# a_402_462# a_147_462# sky130_fd_pr__nfet_01v8_lvt ad=0.147 pd=1.33 as=0.147 ps=1.33 w=1.05 l=0.15
X30 a_832_462# a_200_252# a_746_462# a_147_462# sky130_fd_pr__nfet_01v8_lvt ad=0.147 pd=1.33 as=0.147 ps=1.33 w=1.05 l=0.15
X31 a_402_462# a_200_252# a_2380_462# a_147_462# sky130_fd_pr__nfet_01v8_lvt ad=0.147 pd=1.33 as=0.147 ps=1.33 w=1.05 l=0.15
X32 a_2638_1638# a_200_252# a_2552_1638# a_147_462# sky130_fd_pr__nfet_01v8_lvt ad=0.147 pd=1.33 as=0.147 ps=1.33 w=1.05 l=0.15
X33 a_402_462# a_200_252# a_832_462# a_147_462# sky130_fd_pr__nfet_01v8_lvt ad=0.147 pd=1.33 as=0.147 ps=1.33 w=1.05 l=0.15
X34 a_402_462# a_200_252# a_2380_1638# a_147_462# sky130_fd_pr__nfet_01v8_lvt ad=0.147 pd=1.33 as=0.147 ps=1.33 w=1.05 l=0.15
X35 a_1262_462# a_200_252# a_147_462# a_147_462# sky130_fd_pr__nfet_01v8_lvt ad=0.147 pd=1.33 as=0.147 ps=1.33 w=1.05 l=0.15
X36 a_147_462# a_200_252# a_2122_1638# a_147_462# sky130_fd_pr__nfet_01v8_lvt ad=0.147 pd=1.33 as=0.147 ps=1.33 w=1.05 l=0.15
X37 a_147_462# a_200_252# a_1606_462# a_147_462# sky130_fd_pr__nfet_01v8_lvt ad=0.147 pd=1.33 as=0.147 ps=1.33 w=1.05 l=0.15
X38 a_2294_1638# a_200_252# a_147_462# a_147_462# sky130_fd_pr__nfet_01v8_lvt ad=0.147 pd=1.33 as=0.147 ps=1.33 w=1.05 l=0.15
X39 a_2552_1638# a_200_252# a_402_462# a_147_462# sky130_fd_pr__nfet_01v8_lvt ad=0.147 pd=1.33 as=0.147 ps=1.33 w=1.05 l=0.15
X40 a_574_462# a_200_252# a_488_462# a_147_462# sky130_fd_pr__nfet_01v8_lvt ad=0.147 pd=1.33 as=0.147 ps=1.33 w=1.05 l=0.15
X41 a_147_462# a_200_252# a_2122_462# a_147_462# sky130_fd_pr__nfet_01v8_lvt ad=0.147 pd=1.33 as=0.147 ps=1.33 w=1.05 l=0.15
X42 a_2552_462# a_200_252# a_402_462# a_147_462# sky130_fd_pr__nfet_01v8_lvt ad=0.147 pd=1.33 as=0.147 ps=1.33 w=1.05 l=0.15
X43 a_1004_462# a_200_252# a_402_462# a_147_462# sky130_fd_pr__nfet_01v8_lvt ad=0.147 pd=1.33 as=0.147 ps=1.33 w=1.05 l=0.15
X44 a_2380_1638# a_200_252# a_2294_1638# a_147_462# sky130_fd_pr__nfet_01v8_lvt ad=0.147 pd=1.33 as=0.147 ps=1.33 w=1.05 l=0.15
X45 a_2122_1638# a_200_252# a_2036_1638# a_147_462# sky130_fd_pr__nfet_01v8_lvt ad=0.147 pd=1.33 as=0.147 ps=1.33 w=1.05 l=0.15
X46 a_147_462# a_200_252# a_2638_1638# a_147_462# sky130_fd_pr__nfet_01v8_lvt ad=0.27825 pd=2.63 as=0.147 ps=1.33 w=1.05 l=0.15
X47 a_1348_462# a_200_252# a_1262_462# a_147_462# sky130_fd_pr__nfet_01v8_lvt ad=0.147 pd=1.33 as=0.147 ps=1.33 w=1.05 l=0.15
X48 a_230_462# a_200_252# a_147_462# a_147_462# sky130_fd_pr__nfet_01v8_lvt ad=0.147 pd=1.33 as=0.27825 ps=2.63 w=1.05 l=0.15
X49 a_1778_462# a_200_252# a_147_462# a_147_462# sky130_fd_pr__nfet_01v8_lvt ad=0.147 pd=1.33 as=0.147 ps=1.33 w=1.05 l=0.15
X50 a_316_462# a_200_252# a_230_462# a_147_462# sky130_fd_pr__nfet_01v8_lvt ad=0.147 pd=1.33 as=0.147 ps=1.33 w=1.05 l=0.15
X51 a_147_462# a_200_252# a_574_462# a_147_462# sky130_fd_pr__nfet_01v8_lvt ad=0.147 pd=1.33 as=0.147 ps=1.33 w=1.05 l=0.15
X52 a_2294_462# a_200_252# a_147_462# a_147_462# sky130_fd_pr__nfet_01v8_lvt ad=0.147 pd=1.33 as=0.147 ps=1.33 w=1.05 l=0.15
X53 a_147_462# a_200_252# a_2638_462# a_147_462# sky130_fd_pr__nfet_01v8_lvt ad=0.27825 pd=2.63 as=0.147 ps=1.33 w=1.05 l=0.15
X54 a_2638_462# a_200_252# a_2552_462# a_147_462# sky130_fd_pr__nfet_01v8_lvt ad=0.147 pd=1.33 as=0.147 ps=1.33 w=1.05 l=0.15
X55 a_488_1638# a_200_252# a_402_462# a_147_462# sky130_fd_pr__nfet_01v8_lvt ad=0.147 pd=1.33 as=0.147 ps=1.33 w=1.05 l=0.15
X56 a_746_1638# a_200_252# a_147_462# a_147_462# sky130_fd_pr__nfet_01v8_lvt ad=0.147 pd=1.33 as=0.147 ps=1.33 w=1.05 l=0.15
X57 a_1348_1638# a_200_252# a_1262_1638# a_147_462# sky130_fd_pr__nfet_01v8_lvt ad=0.147 pd=1.33 as=0.147 ps=1.33 w=1.05 l=0.15
X58 a_230_1638# a_200_252# a_147_462# a_147_462# sky130_fd_pr__nfet_01v8_lvt ad=0.147 pd=1.33 as=0.27825 ps=2.63 w=1.05 l=0.15
X59 a_1090_462# a_200_252# a_1004_462# a_147_462# sky130_fd_pr__nfet_01v8_lvt ad=0.147 pd=1.33 as=0.147 ps=1.33 w=1.05 l=0.15
C0 a_1520_462# a_200_252# 0.00249f
C1 a_402_462# a_2122_462# 0.00553f
C2 a_2380_1638# a_200_252# 0.00249f
C3 a_402_462# a_2638_462# 0.00553f
C4 a_574_462# a_402_462# 0.00644f
C5 a_1606_462# a_200_252# 0.00249f
C6 a_1348_462# a_200_252# 0.00249f
C7 a_1004_462# a_200_252# 0.00249f
C8 a_200_252# a_2380_462# 0.00249f
C9 a_1520_462# a_402_462# 0.00819f
C10 a_2380_1638# a_402_462# 0.00819f
C11 a_1864_1638# a_200_252# 0.00249f
C12 a_2036_1638# a_200_252# 0.00249f
C13 a_1520_1638# a_200_252# 0.00249f
C14 a_1606_462# a_402_462# 0.00553f
C15 a_1348_462# a_402_462# 0.01431f
C16 a_1004_462# a_402_462# 0.01034f
C17 a_746_462# a_200_252# 0.00249f
C18 a_746_1638# a_200_252# 0.00356f
C19 a_402_462# a_2380_462# 0.00819f
C20 a_230_1638# a_200_252# 0
C21 a_1864_1638# a_402_462# 0.00819f
C22 a_316_462# a_402_462# 0.00877f
C23 a_200_252# a_1090_1638# 0.00464f
C24 a_2036_1638# a_402_462# 0.00819f
C25 a_1520_1638# a_402_462# 0.00819f
C26 a_1004_1638# a_200_252# 0.00431f
C27 a_402_462# a_230_462# 0.00603f
C28 a_200_252# a_2294_462# 0.00249f
C29 a_1778_462# a_200_252# 0.00249f
C30 a_1090_462# a_200_252# 0.00249f
C31 a_746_462# a_402_462# 0.0068f
C32 a_746_1638# a_402_462# 0.00553f
C33 a_230_1638# a_402_462# 0.00553f
C34 a_402_462# a_1090_1638# 0.00553f
C35 a_1004_1638# a_402_462# 0.00819f
C36 a_402_462# a_2294_462# 0.00553f
C37 a_1778_462# a_402_462# 0.00553f
C38 a_574_1638# a_200_252# 0.00326f
C39 a_1090_462# a_402_462# 0.00804f
C40 a_200_252# a_1606_1638# 0.00249f
C41 a_832_1638# a_200_252# 0.00376f
C42 a_832_462# a_200_252# 0.00249f
C43 a_200_252# a_488_462# 0.00249f
C44 a_574_1638# a_402_462# 0.00553f
C45 a_1262_462# a_200_252# 0.00249f
C46 a_1778_1638# a_200_252# 0.00249f
C47 a_402_462# a_1606_1638# 0.00553f
C48 a_832_1638# a_402_462# 0.00819f
C49 a_832_462# a_402_462# 0.00971f
C50 a_402_462# a_488_462# 0.00896f
C51 a_2638_1638# a_402_462# 0.00553f
C52 a_200_252# a_2036_462# 0.00249f
C53 a_1262_462# a_402_462# 0.00856f
C54 a_1778_1638# a_402_462# 0.00553f
C55 a_200_252# a_2122_1638# 0.00249f
C56 a_402_462# a_2036_462# 0.00819f
C57 a_402_462# a_2552_462# 0.00819f
C58 a_402_462# a_200_252# 2.04947f
C59 a_1348_1638# a_200_252# 0.00552f
C60 a_402_462# a_2122_1638# 0.00553f
C61 a_488_1638# a_200_252# 0.00316f
C62 a_316_1638# a_200_252# 0
C63 a_2552_1638# a_402_462# 0.00819f
C64 a_2294_1638# a_200_252# 0.00249f
C65 a_1864_462# a_200_252# 0.00249f
C66 a_1348_1638# a_402_462# 0.00984f
C67 a_488_1638# a_402_462# 0.00819f
C68 a_316_1638# a_402_462# 0.00819f
C69 a_1262_1638# a_200_252# 0.00532f
C70 a_200_252# a_2122_462# 0.00249f
C71 a_2294_1638# a_402_462# 0.00553f
C72 a_1864_462# a_402_462# 0.00819f
C73 a_574_462# a_200_252# 0.00249f
C74 a_1262_1638# a_402_462# 0.00553f
C75 a_2638_462# a_147_462# 0.01162f
C76 a_2552_462# a_147_462# 0.00903f
C77 a_2380_462# a_147_462# 0.00848f
C78 a_2294_462# a_147_462# 0.01127f
C79 a_2122_462# a_147_462# 0.01163f
C80 a_2036_462# a_147_462# 0.00922f
C81 a_1864_462# a_147_462# 0.00985f
C82 a_1778_462# a_147_462# 0.01287f
C83 a_1606_462# a_147_462# 0.0134f
C84 a_1520_462# a_147_462# 0.01382f
C85 a_1348_462# a_147_462# 0.0077f
C86 a_1262_462# a_147_462# 0.01036f
C87 a_1090_462# a_147_462# 0.01036f
C88 a_1004_462# a_147_462# 0.0077f
C89 a_832_462# a_147_462# 0.0077f
C90 a_746_462# a_147_462# 0.01036f
C91 a_574_462# a_147_462# 0.01036f
C92 a_488_462# a_147_462# 0.0077f
C93 a_316_462# a_147_462# 0.00845f
C94 a_230_462# a_147_462# 0.01111f
C95 a_2638_1638# a_147_462# 0.01087f
C96 a_2552_1638# a_147_462# 0.00828f
C97 a_2380_1638# a_147_462# 0.00848f
C98 a_2294_1638# a_147_462# 0.01127f
C99 a_2122_1638# a_147_462# 0.01163f
C100 a_2036_1638# a_147_462# 0.00922f
C101 a_1864_1638# a_147_462# 0.00985f
C102 a_1778_1638# a_147_462# 0.01287f
C103 a_1606_1638# a_147_462# 0.0134f
C104 a_1520_1638# a_147_462# 0.01382f
C105 a_1348_1638# a_147_462# 0.0077f
C106 a_1262_1638# a_147_462# 0.01036f
C107 a_1090_1638# a_147_462# 0.01036f
C108 a_1004_1638# a_147_462# 0.0077f
C109 a_832_1638# a_147_462# 0.0077f
C110 a_746_1638# a_147_462# 0.01036f
C111 a_574_1638# a_147_462# 0.01036f
C112 a_488_1638# a_147_462# 0.0077f
C113 a_402_462# a_147_462# 6.82242f
C114 a_316_1638# a_147_462# 0.0077f
C115 a_230_1638# a_147_462# 0.01036f
C116 a_200_252# a_147_462# 14.7422f
.ends

.subckt PMOS_S_70655723_X5_Y2_1782175708_1782175707 a_200_252# a_402_462# w_0_0# VSUBS
X0 a_402_462# a_200_252# a_316_1638# w_0_0# sky130_fd_pr__pfet_01v8_lvt ad=0.147 pd=1.33 as=0.147 ps=1.33 w=1.05 l=0.15
X1 w_0_0# a_200_252# a_574_1638# w_0_0# sky130_fd_pr__pfet_01v8_lvt ad=0.147 pd=1.33 as=0.147 ps=1.33 w=1.05 l=0.15
X2 a_1262_1638# a_200_252# w_0_0# w_0_0# sky130_fd_pr__pfet_01v8_lvt ad=0.147 pd=1.33 as=0.147 ps=1.33 w=1.05 l=0.15
X3 a_1004_1638# a_200_252# a_402_462# w_0_0# sky130_fd_pr__pfet_01v8_lvt ad=0.147 pd=1.33 as=0.147 ps=1.33 w=1.05 l=0.15
X4 a_1864_1638# a_200_252# a_1778_1638# w_0_0# sky130_fd_pr__pfet_01v8_lvt ad=0.147 pd=1.33 as=0.147 ps=1.33 w=1.05 l=0.15
X5 a_746_462# a_200_252# w_0_0# w_0_0# sky130_fd_pr__pfet_01v8_lvt ad=0.147 pd=1.33 as=0.147 ps=1.33 w=1.05 l=0.15
X6 a_1606_1638# a_200_252# a_1520_1638# w_0_0# sky130_fd_pr__pfet_01v8_lvt ad=0.147 pd=1.33 as=0.147 ps=1.33 w=1.05 l=0.15
X7 a_1090_1638# a_200_252# a_1004_1638# w_0_0# sky130_fd_pr__pfet_01v8_lvt ad=0.147 pd=1.33 as=0.147 ps=1.33 w=1.05 l=0.15
X8 a_402_462# a_200_252# a_1864_1638# w_0_0# sky130_fd_pr__pfet_01v8_lvt ad=0.147 pd=1.33 as=0.147 ps=1.33 w=1.05 l=0.15
X9 w_0_0# a_200_252# a_1606_1638# w_0_0# sky130_fd_pr__pfet_01v8_lvt ad=0.147 pd=1.33 as=0.147 ps=1.33 w=1.05 l=0.15
X10 w_0_0# a_200_252# a_1090_462# w_0_0# sky130_fd_pr__pfet_01v8_lvt ad=0.147 pd=1.33 as=0.147 ps=1.33 w=1.05 l=0.15
X11 a_1606_462# a_200_252# a_1520_462# w_0_0# sky130_fd_pr__pfet_01v8_lvt ad=0.147 pd=1.33 as=0.147 ps=1.33 w=1.05 l=0.15
X12 a_402_462# a_200_252# a_1864_462# w_0_0# sky130_fd_pr__pfet_01v8_lvt ad=0.147 pd=1.33 as=0.147 ps=1.33 w=1.05 l=0.15
X13 a_1520_1638# a_200_252# a_402_462# w_0_0# sky130_fd_pr__pfet_01v8_lvt ad=0.147 pd=1.33 as=0.147 ps=1.33 w=1.05 l=0.15
X14 a_2036_462# a_200_252# a_402_462# w_0_0# sky130_fd_pr__pfet_01v8_lvt ad=0.147 pd=1.33 as=0.147 ps=1.33 w=1.05 l=0.15
X15 a_2122_462# a_200_252# a_2036_462# w_0_0# sky130_fd_pr__pfet_01v8_lvt ad=0.147 pd=1.33 as=0.147 ps=1.33 w=1.05 l=0.15
X16 a_488_462# a_200_252# a_402_462# w_0_0# sky130_fd_pr__pfet_01v8_lvt ad=0.147 pd=1.33 as=0.147 ps=1.33 w=1.05 l=0.15
X17 a_832_462# a_200_252# a_746_462# w_0_0# sky130_fd_pr__pfet_01v8_lvt ad=0.147 pd=1.33 as=0.147 ps=1.33 w=1.05 l=0.15
X18 a_402_462# a_200_252# a_2380_462# w_0_0# sky130_fd_pr__pfet_01v8_lvt ad=0.147 pd=1.33 as=0.147 ps=1.33 w=1.05 l=0.15
X19 a_2036_1638# a_200_252# a_402_462# w_0_0# sky130_fd_pr__pfet_01v8_lvt ad=0.147 pd=1.33 as=0.147 ps=1.33 w=1.05 l=0.15
X20 a_2638_1638# a_200_252# a_2552_1638# w_0_0# sky130_fd_pr__pfet_01v8_lvt ad=0.147 pd=1.33 as=0.147 ps=1.33 w=1.05 l=0.15
X21 a_402_462# a_200_252# a_832_462# w_0_0# sky130_fd_pr__pfet_01v8_lvt ad=0.147 pd=1.33 as=0.147 ps=1.33 w=1.05 l=0.15
X22 a_1262_462# a_200_252# w_0_0# w_0_0# sky130_fd_pr__pfet_01v8_lvt ad=0.147 pd=1.33 as=0.147 ps=1.33 w=1.05 l=0.15
X23 w_0_0# a_200_252# a_2122_1638# w_0_0# sky130_fd_pr__pfet_01v8_lvt ad=0.147 pd=1.33 as=0.147 ps=1.33 w=1.05 l=0.15
X24 a_402_462# a_200_252# a_2380_1638# w_0_0# sky130_fd_pr__pfet_01v8_lvt ad=0.147 pd=1.33 as=0.147 ps=1.33 w=1.05 l=0.15
X25 w_0_0# a_200_252# a_1606_462# w_0_0# sky130_fd_pr__pfet_01v8_lvt ad=0.147 pd=1.33 as=0.147 ps=1.33 w=1.05 l=0.15
X26 a_2552_1638# a_200_252# a_402_462# w_0_0# sky130_fd_pr__pfet_01v8_lvt ad=0.147 pd=1.33 as=0.147 ps=1.33 w=1.05 l=0.15
X27 a_2294_1638# a_200_252# w_0_0# w_0_0# sky130_fd_pr__pfet_01v8_lvt ad=0.147 pd=1.33 as=0.147 ps=1.33 w=1.05 l=0.15
X28 a_574_462# a_200_252# a_488_462# w_0_0# sky130_fd_pr__pfet_01v8_lvt ad=0.147 pd=1.33 as=0.147 ps=1.33 w=1.05 l=0.15
X29 w_0_0# a_200_252# a_2122_462# w_0_0# sky130_fd_pr__pfet_01v8_lvt ad=0.147 pd=1.33 as=0.147 ps=1.33 w=1.05 l=0.15
X30 a_2552_462# a_200_252# a_402_462# w_0_0# sky130_fd_pr__pfet_01v8_lvt ad=0.147 pd=1.33 as=0.147 ps=1.33 w=1.05 l=0.15
X31 a_1004_462# a_200_252# a_402_462# w_0_0# sky130_fd_pr__pfet_01v8_lvt ad=0.147 pd=1.33 as=0.147 ps=1.33 w=1.05 l=0.15
X32 a_2380_1638# a_200_252# a_2294_1638# w_0_0# sky130_fd_pr__pfet_01v8_lvt ad=0.147 pd=1.33 as=0.147 ps=1.33 w=1.05 l=0.15
X33 a_2122_1638# a_200_252# a_2036_1638# w_0_0# sky130_fd_pr__pfet_01v8_lvt ad=0.147 pd=1.33 as=0.147 ps=1.33 w=1.05 l=0.15
X34 w_0_0# a_200_252# a_2638_1638# w_0_0# sky130_fd_pr__pfet_01v8_lvt ad=0.27825 pd=2.63 as=0.147 ps=1.33 w=1.05 l=0.15
X35 a_1348_462# a_200_252# a_1262_462# w_0_0# sky130_fd_pr__pfet_01v8_lvt ad=0.147 pd=1.33 as=0.147 ps=1.33 w=1.05 l=0.15
X36 a_230_462# a_200_252# w_0_0# w_0_0# sky130_fd_pr__pfet_01v8_lvt ad=0.147 pd=1.33 as=0.27825 ps=2.63 w=1.05 l=0.15
X37 a_316_462# a_200_252# a_230_462# w_0_0# sky130_fd_pr__pfet_01v8_lvt ad=0.147 pd=1.33 as=0.147 ps=1.33 w=1.05 l=0.15
X38 a_1778_462# a_200_252# w_0_0# w_0_0# sky130_fd_pr__pfet_01v8_lvt ad=0.147 pd=1.33 as=0.147 ps=1.33 w=1.05 l=0.15
X39 a_2294_462# a_200_252# w_0_0# w_0_0# sky130_fd_pr__pfet_01v8_lvt ad=0.147 pd=1.33 as=0.147 ps=1.33 w=1.05 l=0.15
X40 w_0_0# a_200_252# a_574_462# w_0_0# sky130_fd_pr__pfet_01v8_lvt ad=0.147 pd=1.33 as=0.147 ps=1.33 w=1.05 l=0.15
X41 a_2638_462# a_200_252# a_2552_462# w_0_0# sky130_fd_pr__pfet_01v8_lvt ad=0.147 pd=1.33 as=0.147 ps=1.33 w=1.05 l=0.15
X42 w_0_0# a_200_252# a_2638_462# w_0_0# sky130_fd_pr__pfet_01v8_lvt ad=0.27825 pd=2.63 as=0.147 ps=1.33 w=1.05 l=0.15
X43 a_746_1638# a_200_252# w_0_0# w_0_0# sky130_fd_pr__pfet_01v8_lvt ad=0.147 pd=1.33 as=0.147 ps=1.33 w=1.05 l=0.15
X44 a_1348_1638# a_200_252# a_1262_1638# w_0_0# sky130_fd_pr__pfet_01v8_lvt ad=0.147 pd=1.33 as=0.147 ps=1.33 w=1.05 l=0.15
X45 a_488_1638# a_200_252# a_402_462# w_0_0# sky130_fd_pr__pfet_01v8_lvt ad=0.147 pd=1.33 as=0.147 ps=1.33 w=1.05 l=0.15
X46 a_1090_462# a_200_252# a_1004_462# w_0_0# sky130_fd_pr__pfet_01v8_lvt ad=0.147 pd=1.33 as=0.147 ps=1.33 w=1.05 l=0.15
X47 a_230_1638# a_200_252# w_0_0# w_0_0# sky130_fd_pr__pfet_01v8_lvt ad=0.147 pd=1.33 as=0.27825 ps=2.63 w=1.05 l=0.15
X48 a_574_1638# a_200_252# a_488_1638# w_0_0# sky130_fd_pr__pfet_01v8_lvt ad=0.147 pd=1.33 as=0.147 ps=1.33 w=1.05 l=0.15
X49 a_832_1638# a_200_252# a_746_1638# w_0_0# sky130_fd_pr__pfet_01v8_lvt ad=0.147 pd=1.33 as=0.147 ps=1.33 w=1.05 l=0.15
X50 w_0_0# a_200_252# a_1090_1638# w_0_0# sky130_fd_pr__pfet_01v8_lvt ad=0.147 pd=1.33 as=0.147 ps=1.33 w=1.05 l=0.15
X51 a_402_462# a_200_252# a_1348_1638# w_0_0# sky130_fd_pr__pfet_01v8_lvt ad=0.147 pd=1.33 as=0.147 ps=1.33 w=1.05 l=0.15
X52 a_402_462# a_200_252# a_1348_462# w_0_0# sky130_fd_pr__pfet_01v8_lvt ad=0.147 pd=1.33 as=0.147 ps=1.33 w=1.05 l=0.15
X53 a_1520_462# a_200_252# a_402_462# w_0_0# sky130_fd_pr__pfet_01v8_lvt ad=0.147 pd=1.33 as=0.147 ps=1.33 w=1.05 l=0.15
X54 a_316_1638# a_200_252# a_230_1638# w_0_0# sky130_fd_pr__pfet_01v8_lvt ad=0.147 pd=1.33 as=0.147 ps=1.33 w=1.05 l=0.15
X55 a_1778_1638# a_200_252# w_0_0# w_0_0# sky130_fd_pr__pfet_01v8_lvt ad=0.147 pd=1.33 as=0.147 ps=1.33 w=1.05 l=0.15
X56 a_1864_462# a_200_252# a_1778_462# w_0_0# sky130_fd_pr__pfet_01v8_lvt ad=0.147 pd=1.33 as=0.147 ps=1.33 w=1.05 l=0.15
X57 a_402_462# a_200_252# a_832_1638# w_0_0# sky130_fd_pr__pfet_01v8_lvt ad=0.147 pd=1.33 as=0.147 ps=1.33 w=1.05 l=0.15
X58 a_402_462# a_200_252# a_316_462# w_0_0# sky130_fd_pr__pfet_01v8_lvt ad=0.147 pd=1.33 as=0.147 ps=1.33 w=1.05 l=0.15
X59 a_2380_462# a_200_252# a_2294_462# w_0_0# sky130_fd_pr__pfet_01v8_lvt ad=0.147 pd=1.33 as=0.147 ps=1.33 w=1.05 l=0.15
C0 a_574_1638# a_200_252# 0.00326f
C1 a_1520_1638# a_200_252# 0.00249f
C2 a_1606_462# w_0_0# 0.0134f
C3 a_746_462# a_200_252# 0.00249f
C4 a_1348_1638# w_0_0# 0.0077f
C5 a_316_1638# w_0_0# 0.0077f
C6 a_1606_462# a_402_462# 0.00553f
C7 a_832_462# a_200_252# 0.00249f
C8 a_1348_1638# a_402_462# 0.00984f
C9 a_316_1638# a_402_462# 0.00819f
C10 a_746_1638# a_200_252# 0.00356f
C11 a_1778_1638# a_200_252# 0.00249f
C12 w_0_0# a_230_462# 0.01111f
C13 a_1004_1638# w_0_0# 0.0077f
C14 a_402_462# a_230_462# 0.00603f
C15 a_1004_1638# a_402_462# 0.00819f
C16 a_1864_462# w_0_0# 0.00985f
C17 a_832_1638# w_0_0# 0.0077f
C18 a_1864_462# a_402_462# 0.00819f
C19 a_2036_462# w_0_0# 0.00922f
C20 a_832_1638# a_402_462# 0.00819f
C21 a_1090_462# a_200_252# 0.00249f
C22 a_2036_462# a_402_462# 0.00819f
C23 a_230_1638# w_0_0# 0.01036f
C24 a_1262_462# w_0_0# 0.01036f
C25 w_0_0# a_2380_462# 0.00848f
C26 a_2122_1638# a_200_252# 0.00249f
C27 a_488_1638# a_200_252# 0.00316f
C28 a_402_462# a_230_1638# 0.00553f
C29 a_1262_462# a_402_462# 0.00856f
C30 a_402_462# a_2380_462# 0.00819f
C31 a_574_462# w_0_0# 0.01036f
C32 a_1348_462# a_200_252# 0.00249f
C33 a_574_462# a_402_462# 0.00644f
C34 a_2552_1638# w_0_0# 0.00828f
C35 a_2552_1638# a_402_462# 0.00819f
C36 a_1778_462# a_200_252# 0.00249f
C37 a_1606_1638# w_0_0# 0.0134f
C38 a_1606_1638# a_402_462# 0.00553f
C39 a_1606_462# a_200_252# 0.00249f
C40 a_1348_1638# a_200_252# 0.00552f
C41 a_316_1638# a_200_252# 0
C42 a_2380_1638# w_0_0# 0.00848f
C43 a_2380_1638# a_402_462# 0.00819f
C44 a_2036_1638# w_0_0# 0.00922f
C45 a_1520_462# w_0_0# 0.01382f
C46 a_2036_1638# a_402_462# 0.00819f
C47 a_1004_1638# a_200_252# 0.00431f
C48 a_1520_462# a_402_462# 0.00819f
C49 a_2122_462# w_0_0# 0.01163f
C50 w_0_0# a_2638_1638# 0.01087f
C51 a_1864_462# a_200_252# 0.00249f
C52 a_2122_462# a_402_462# 0.00553f
C53 a_402_462# a_2638_1638# 0.00553f
C54 a_832_1638# a_200_252# 0.00376f
C55 a_2036_462# a_200_252# 0.00249f
C56 a_1004_462# w_0_0# 0.0077f
C57 a_402_462# w_0_0# 6.27844f
C58 a_230_1638# a_200_252# 0
C59 a_1004_462# a_402_462# 0.01034f
C60 a_1262_462# a_200_252# 0.00249f
C61 a_200_252# a_2380_462# 0.00249f
C62 a_1864_1638# w_0_0# 0.00985f
C63 a_1090_1638# w_0_0# 0.01036f
C64 a_1864_1638# a_402_462# 0.00819f
C65 a_1090_1638# a_402_462# 0.00553f
C66 a_574_462# a_200_252# 0.00249f
C67 w_0_0# a_2294_462# 0.01127f
C68 a_402_462# a_2294_462# 0.00553f
C69 a_316_462# w_0_0# 0.00845f
C70 a_2294_1638# w_0_0# 0.01127f
C71 a_316_462# a_402_462# 0.00877f
C72 a_1262_1638# w_0_0# 0.01036f
C73 a_1606_1638# a_200_252# 0.00249f
C74 a_488_462# w_0_0# 0.0077f
C75 a_2294_1638# a_402_462# 0.00553f
C76 a_1262_1638# a_402_462# 0.00553f
C77 a_488_462# a_402_462# 0.00896f
C78 a_574_1638# w_0_0# 0.01036f
C79 a_1520_1638# w_0_0# 0.01382f
C80 a_574_1638# a_402_462# 0.00553f
C81 a_746_462# w_0_0# 0.01036f
C82 a_1520_1638# a_402_462# 0.00819f
C83 a_832_462# w_0_0# 0.0077f
C84 a_746_462# a_402_462# 0.0068f
C85 a_2380_1638# a_200_252# 0.00249f
C86 a_746_1638# w_0_0# 0.01036f
C87 a_1778_1638# w_0_0# 0.01287f
C88 a_832_462# a_402_462# 0.00971f
C89 a_2552_462# w_0_0# 0.00903f
C90 a_746_1638# a_402_462# 0.00553f
C91 a_2638_462# w_0_0# 0.01162f
C92 a_2036_1638# a_200_252# 0.00249f
C93 a_1778_1638# a_402_462# 0.00553f
C94 a_2552_462# a_402_462# 0.00819f
C95 a_1520_462# a_200_252# 0.00249f
C96 a_2638_462# a_402_462# 0.00553f
C97 a_2122_462# a_200_252# 0.00249f
C98 a_1090_462# w_0_0# 0.01036f
C99 a_1090_462# a_402_462# 0.00804f
C100 a_200_252# w_0_0# 14.3171f
C101 a_1004_462# a_200_252# 0.00249f
C102 a_2122_1638# w_0_0# 0.01163f
C103 a_402_462# a_200_252# 2.04947f
C104 a_488_1638# w_0_0# 0.0077f
C105 a_2122_1638# a_402_462# 0.00553f
C106 a_488_1638# a_402_462# 0.00819f
C107 a_1864_1638# a_200_252# 0.00249f
C108 a_1090_1638# a_200_252# 0.00464f
C109 a_1348_462# w_0_0# 0.0077f
C110 a_200_252# a_2294_462# 0.00249f
C111 a_1348_462# a_402_462# 0.01431f
C112 a_1778_462# w_0_0# 0.01287f
C113 a_1778_462# a_402_462# 0.00553f
C114 a_2294_1638# a_200_252# 0.00249f
C115 a_1262_1638# a_200_252# 0.00532f
C116 a_488_462# a_200_252# 0.00249f
C117 a_402_462# VSUBS 0.54398f
C118 a_200_252# VSUBS 0.42514f
C119 w_0_0# VSUBS 23.4212f
.ends

.subckt INV_3799024_0_0_1782175707 m2_1434_1764# m2_1348_2604# PMOS_S_70655723_X5_Y2_1782175708_1782175707_0/w_0_0#
+ VSUBS
XNMOS_S_10961373_X5_Y2_1782175707_1782175707_0 m2_1434_1764# m2_1348_2604# VSUBS NMOS_S_10961373_X5_Y2_1782175707_1782175707
XPMOS_S_70655723_X5_Y2_1782175708_1782175707_0 m2_1434_1764# m2_1348_2604# PMOS_S_70655723_X5_Y2_1782175708_1782175707_0/w_0_0#
+ VSUBS PMOS_S_70655723_X5_Y2_1782175708_1782175707
C0 PMOS_S_70655723_X5_Y2_1782175708_1782175707_0/w_0_0# m2_1434_1764# 0.50643f
C1 PMOS_S_70655723_X5_Y2_1782175708_1782175707_0/w_0_0# m2_1348_2604# -0.19323f
C2 m2_1434_1764# m2_1348_2604# 1.12471f
C3 PMOS_S_70655723_X5_Y2_1782175708_1782175707_0/w_0_0# VSUBS 0.15426f
C4 m2_1348_2604# VSUBS -1.07615f
C5 m2_1434_1764# VSUBS 0.37526f
.ends

.subckt INVERTER_0
XINV_3799024_0_0_1782175707_0 IN OUT VDD VSS INV_3799024_0_0_1782175707
C0 OUT VSS -0.89782f
C1 IN VSS -0.8105f
.ends
