* NGSPICE file created from INVERTER.ext - technology: sky130A

.subckt INVERTER OUT IN VSS VDD
X0 a_1606_840# IN a_1520_840# VSS sky130_fd_pr__nfet_01v8_lvt ad=0.147 pd=1.33 as=0.147 ps=1.33 w=1.05 l=0.15
X1 VSS IN a_1606_2016# VSS sky130_fd_pr__nfet_01v8_lvt ad=0.147 pd=1.33 as=0.147 ps=1.33 w=1.05 l=0.15
X2 OUT IN a_1864_840# VSS sky130_fd_pr__nfet_01v8_lvt ad=0.147 pd=1.33 as=0.147 ps=1.33 w=1.05 l=0.15
X3 a_230_3150# IN VDD VDD sky130_fd_pr__pfet_01v8_lvt ad=0.147 pd=1.33 as=0.27825 ps=2.63 w=1.05 l=0.15
X4 a_2122_840# IN a_2036_840# VSS sky130_fd_pr__nfet_01v8_lvt ad=0.147 pd=1.33 as=0.147 ps=1.33 w=1.05 l=0.15
X5 a_2380_4326# IN a_2294_4326# VDD sky130_fd_pr__pfet_01v8_lvt ad=0.147 pd=1.33 as=0.147 ps=1.33 w=1.05 l=0.15
X6 a_2036_840# IN OUT VSS sky130_fd_pr__nfet_01v8_lvt ad=0.147 pd=1.33 as=0.147 ps=1.33 w=1.05 l=0.15
X7 OUT IN a_1348_3150# VDD sky130_fd_pr__pfet_01v8_lvt ad=0.147 pd=1.33 as=0.147 ps=1.33 w=1.05 l=0.15
X8 a_832_3150# IN a_746_3150# VDD sky130_fd_pr__pfet_01v8_lvt ad=0.147 pd=1.33 as=0.147 ps=1.33 w=1.05 l=0.15
X9 a_2122_4326# IN a_2036_4326# VDD sky130_fd_pr__pfet_01v8_lvt ad=0.147 pd=1.33 as=0.147 ps=1.33 w=1.05 l=0.15
X10 VDD IN a_1090_3150# VDD sky130_fd_pr__pfet_01v8_lvt ad=0.147 pd=1.33 as=0.147 ps=1.33 w=1.05 l=0.15
X11 a_574_3150# IN a_488_3150# VDD sky130_fd_pr__pfet_01v8_lvt ad=0.147 pd=1.33 as=0.147 ps=1.33 w=1.05 l=0.15
X12 OUT IN a_2380_840# VSS sky130_fd_pr__nfet_01v8_lvt ad=0.147 pd=1.33 as=0.147 ps=1.33 w=1.05 l=0.15
X13 a_488_840# IN OUT VSS sky130_fd_pr__nfet_01v8_lvt ad=0.147 pd=1.33 as=0.147 ps=1.33 w=1.05 l=0.15
X14 a_832_840# IN a_746_840# VSS sky130_fd_pr__nfet_01v8_lvt ad=0.147 pd=1.33 as=0.147 ps=1.33 w=1.05 l=0.15
X15 a_316_3150# IN a_230_3150# VDD sky130_fd_pr__pfet_01v8_lvt ad=0.147 pd=1.33 as=0.147 ps=1.33 w=1.05 l=0.15
X16 VDD IN a_2638_4326# VDD sky130_fd_pr__pfet_01v8_lvt ad=0.27825 pd=2.63 as=0.147 ps=1.33 w=1.05 l=0.15
X17 a_1520_2016# IN OUT VSS sky130_fd_pr__nfet_01v8_lvt ad=0.147 pd=1.33 as=0.147 ps=1.33 w=1.05 l=0.15
X18 a_1778_3150# IN VDD VDD sky130_fd_pr__pfet_01v8_lvt ad=0.147 pd=1.33 as=0.147 ps=1.33 w=1.05 l=0.15
X19 OUT IN a_832_840# VSS sky130_fd_pr__nfet_01v8_lvt ad=0.147 pd=1.33 as=0.147 ps=1.33 w=1.05 l=0.15
X20 OUT IN a_832_3150# VDD sky130_fd_pr__pfet_01v8_lvt ad=0.147 pd=1.33 as=0.147 ps=1.33 w=1.05 l=0.15
X21 a_2036_2016# IN OUT VSS sky130_fd_pr__nfet_01v8_lvt ad=0.147 pd=1.33 as=0.147 ps=1.33 w=1.05 l=0.15
X22 a_1262_3150# IN VDD VDD sky130_fd_pr__pfet_01v8_lvt ad=0.147 pd=1.33 as=0.147 ps=1.33 w=1.05 l=0.15
X23 VDD IN a_574_3150# VDD sky130_fd_pr__pfet_01v8_lvt ad=0.147 pd=1.33 as=0.147 ps=1.33 w=1.05 l=0.15
X24 OUT IN a_316_3150# VDD sky130_fd_pr__pfet_01v8_lvt ad=0.147 pd=1.33 as=0.147 ps=1.33 w=1.05 l=0.15
X25 a_2638_2016# IN a_2552_2016# VSS sky130_fd_pr__nfet_01v8_lvt ad=0.147 pd=1.33 as=0.147 ps=1.33 w=1.05 l=0.15
X26 a_1864_3150# IN a_1778_3150# VDD sky130_fd_pr__pfet_01v8_lvt ad=0.147 pd=1.33 as=0.147 ps=1.33 w=1.05 l=0.15
X27 a_1004_3150# IN OUT VDD sky130_fd_pr__pfet_01v8_lvt ad=0.147 pd=1.33 as=0.147 ps=1.33 w=1.05 l=0.15
X28 a_1606_3150# IN a_1520_3150# VDD sky130_fd_pr__pfet_01v8_lvt ad=0.147 pd=1.33 as=0.147 ps=1.33 w=1.05 l=0.15
X29 a_1262_840# IN VSS VSS sky130_fd_pr__nfet_01v8_lvt ad=0.147 pd=1.33 as=0.147 ps=1.33 w=1.05 l=0.15
X30 VSS IN a_1606_840# VSS sky130_fd_pr__nfet_01v8_lvt ad=0.147 pd=1.33 as=0.147 ps=1.33 w=1.05 l=0.15
X31 a_1090_3150# IN a_1004_3150# VDD sky130_fd_pr__pfet_01v8_lvt ad=0.147 pd=1.33 as=0.147 ps=1.33 w=1.05 l=0.15
X32 OUT IN a_1864_3150# VDD sky130_fd_pr__pfet_01v8_lvt ad=0.147 pd=1.33 as=0.147 ps=1.33 w=1.05 l=0.15
X33 OUT IN a_2380_2016# VSS sky130_fd_pr__nfet_01v8_lvt ad=0.147 pd=1.33 as=0.147 ps=1.33 w=1.05 l=0.15
X34 a_746_4326# IN VDD VDD sky130_fd_pr__pfet_01v8_lvt ad=0.147 pd=1.33 as=0.147 ps=1.33 w=1.05 l=0.15
X35 a_1348_4326# IN a_1262_4326# VDD sky130_fd_pr__pfet_01v8_lvt ad=0.147 pd=1.33 as=0.147 ps=1.33 w=1.05 l=0.15
X36 VDD IN a_1606_3150# VDD sky130_fd_pr__pfet_01v8_lvt ad=0.147 pd=1.33 as=0.147 ps=1.33 w=1.05 l=0.15
X37 a_488_4326# IN OUT VDD sky130_fd_pr__pfet_01v8_lvt ad=0.147 pd=1.33 as=0.147 ps=1.33 w=1.05 l=0.15
X38 VSS IN a_2122_2016# VSS sky130_fd_pr__nfet_01v8_lvt ad=0.147 pd=1.33 as=0.147 ps=1.33 w=1.05 l=0.15
X39 VSS IN a_2122_840# VSS sky130_fd_pr__nfet_01v8_lvt ad=0.147 pd=1.33 as=0.147 ps=1.33 w=1.05 l=0.15
X40 a_230_4326# IN VDD VDD sky130_fd_pr__pfet_01v8_lvt ad=0.147 pd=1.33 as=0.27825 ps=2.63 w=1.05 l=0.15
X41 a_2552_840# IN OUT VSS sky130_fd_pr__nfet_01v8_lvt ad=0.147 pd=1.33 as=0.147 ps=1.33 w=1.05 l=0.15
X42 a_574_840# IN a_488_840# VSS sky130_fd_pr__nfet_01v8_lvt ad=0.147 pd=1.33 as=0.147 ps=1.33 w=1.05 l=0.15
X43 a_832_4326# IN a_746_4326# VDD sky130_fd_pr__pfet_01v8_lvt ad=0.147 pd=1.33 as=0.147 ps=1.33 w=1.05 l=0.15
X44 OUT IN a_1348_4326# VDD sky130_fd_pr__pfet_01v8_lvt ad=0.147 pd=1.33 as=0.147 ps=1.33 w=1.05 l=0.15
X45 a_1004_840# IN OUT VSS sky130_fd_pr__nfet_01v8_lvt ad=0.147 pd=1.33 as=0.147 ps=1.33 w=1.05 l=0.15
X46 a_2552_2016# IN OUT VSS sky130_fd_pr__nfet_01v8_lvt ad=0.147 pd=1.33 as=0.147 ps=1.33 w=1.05 l=0.15
X47 a_2294_2016# IN VSS VSS sky130_fd_pr__nfet_01v8_lvt ad=0.147 pd=1.33 as=0.147 ps=1.33 w=1.05 l=0.15
X48 a_574_4326# IN a_488_4326# VDD sky130_fd_pr__pfet_01v8_lvt ad=0.147 pd=1.33 as=0.147 ps=1.33 w=1.05 l=0.15
X49 VDD IN a_1090_4326# VDD sky130_fd_pr__pfet_01v8_lvt ad=0.147 pd=1.33 as=0.147 ps=1.33 w=1.05 l=0.15
X50 a_1520_3150# IN OUT VDD sky130_fd_pr__pfet_01v8_lvt ad=0.147 pd=1.33 as=0.147 ps=1.33 w=1.05 l=0.15
X51 a_316_4326# IN a_230_4326# VDD sky130_fd_pr__pfet_01v8_lvt ad=0.147 pd=1.33 as=0.147 ps=1.33 w=1.05 l=0.15
X52 a_1778_4326# IN VDD VDD sky130_fd_pr__pfet_01v8_lvt ad=0.147 pd=1.33 as=0.147 ps=1.33 w=1.05 l=0.15
X53 OUT IN a_832_4326# VDD sky130_fd_pr__pfet_01v8_lvt ad=0.147 pd=1.33 as=0.147 ps=1.33 w=1.05 l=0.15
X54 a_2036_3150# IN OUT VDD sky130_fd_pr__pfet_01v8_lvt ad=0.147 pd=1.33 as=0.147 ps=1.33 w=1.05 l=0.15
X55 a_2380_2016# IN a_2294_2016# VSS sky130_fd_pr__nfet_01v8_lvt ad=0.147 pd=1.33 as=0.147 ps=1.33 w=1.05 l=0.15
X56 VDD IN a_574_4326# VDD sky130_fd_pr__pfet_01v8_lvt ad=0.147 pd=1.33 as=0.147 ps=1.33 w=1.05 l=0.15
X57 a_1262_4326# IN VDD VDD sky130_fd_pr__pfet_01v8_lvt ad=0.147 pd=1.33 as=0.147 ps=1.33 w=1.05 l=0.15
X58 a_2638_3150# IN a_2552_3150# VDD sky130_fd_pr__pfet_01v8_lvt ad=0.147 pd=1.33 as=0.147 ps=1.33 w=1.05 l=0.15
X59 OUT IN a_316_4326# VDD sky130_fd_pr__pfet_01v8_lvt ad=0.147 pd=1.33 as=0.147 ps=1.33 w=1.05 l=0.15
X60 a_2122_2016# IN a_2036_2016# VSS sky130_fd_pr__nfet_01v8_lvt ad=0.147 pd=1.33 as=0.147 ps=1.33 w=1.05 l=0.15
X61 a_1864_4326# IN a_1778_4326# VDD sky130_fd_pr__pfet_01v8_lvt ad=0.147 pd=1.33 as=0.147 ps=1.33 w=1.05 l=0.15
X62 a_1348_840# IN a_1262_840# VSS sky130_fd_pr__nfet_01v8_lvt ad=0.147 pd=1.33 as=0.147 ps=1.33 w=1.05 l=0.15
X63 a_1004_4326# IN OUT VDD sky130_fd_pr__pfet_01v8_lvt ad=0.147 pd=1.33 as=0.147 ps=1.33 w=1.05 l=0.15
X64 VSS IN a_2638_2016# VSS sky130_fd_pr__nfet_01v8_lvt ad=0.27825 pd=2.63 as=0.147 ps=1.33 w=1.05 l=0.15
X65 a_1606_4326# IN a_1520_4326# VDD sky130_fd_pr__pfet_01v8_lvt ad=0.147 pd=1.33 as=0.147 ps=1.33 w=1.05 l=0.15
X66 a_1778_840# IN VSS VSS sky130_fd_pr__nfet_01v8_lvt ad=0.147 pd=1.33 as=0.147 ps=1.33 w=1.05 l=0.15
X67 a_230_840# IN VSS VSS sky130_fd_pr__nfet_01v8_lvt ad=0.147 pd=1.33 as=0.27825 ps=2.63 w=1.05 l=0.15
X68 a_316_840# IN a_230_840# VSS sky130_fd_pr__nfet_01v8_lvt ad=0.147 pd=1.33 as=0.147 ps=1.33 w=1.05 l=0.15
X69 OUT IN a_2380_3150# VDD sky130_fd_pr__pfet_01v8_lvt ad=0.147 pd=1.33 as=0.147 ps=1.33 w=1.05 l=0.15
X70 a_1090_4326# IN a_1004_4326# VDD sky130_fd_pr__pfet_01v8_lvt ad=0.147 pd=1.33 as=0.147 ps=1.33 w=1.05 l=0.15
X71 a_2294_840# IN VSS VSS sky130_fd_pr__nfet_01v8_lvt ad=0.147 pd=1.33 as=0.147 ps=1.33 w=1.05 l=0.15
X72 OUT IN a_1864_4326# VDD sky130_fd_pr__pfet_01v8_lvt ad=0.147 pd=1.33 as=0.147 ps=1.33 w=1.05 l=0.15
X73 VSS IN a_574_840# VSS sky130_fd_pr__nfet_01v8_lvt ad=0.147 pd=1.33 as=0.147 ps=1.33 w=1.05 l=0.15
X74 VDD IN a_2122_3150# VDD sky130_fd_pr__pfet_01v8_lvt ad=0.147 pd=1.33 as=0.147 ps=1.33 w=1.05 l=0.15
X75 VDD IN a_1606_4326# VDD sky130_fd_pr__pfet_01v8_lvt ad=0.147 pd=1.33 as=0.147 ps=1.33 w=1.05 l=0.15
X76 VSS IN a_2638_840# VSS sky130_fd_pr__nfet_01v8_lvt ad=0.27825 pd=2.63 as=0.147 ps=1.33 w=1.05 l=0.15
X77 a_2638_840# IN a_2552_840# VSS sky130_fd_pr__nfet_01v8_lvt ad=0.147 pd=1.33 as=0.147 ps=1.33 w=1.05 l=0.15
X78 a_2552_3150# IN OUT VDD sky130_fd_pr__pfet_01v8_lvt ad=0.147 pd=1.33 as=0.147 ps=1.33 w=1.05 l=0.15
X79 a_2294_3150# IN VDD VDD sky130_fd_pr__pfet_01v8_lvt ad=0.147 pd=1.33 as=0.147 ps=1.33 w=1.05 l=0.15
X80 a_1090_840# IN a_1004_840# VSS sky130_fd_pr__nfet_01v8_lvt ad=0.147 pd=1.33 as=0.147 ps=1.33 w=1.05 l=0.15
X81 a_1520_4326# IN OUT VDD sky130_fd_pr__pfet_01v8_lvt ad=0.147 pd=1.33 as=0.147 ps=1.33 w=1.05 l=0.15
X82 a_1348_2016# IN a_1262_2016# VSS sky130_fd_pr__nfet_01v8_lvt ad=0.147 pd=1.33 as=0.147 ps=1.33 w=1.05 l=0.15
X83 a_746_2016# IN VSS VSS sky130_fd_pr__nfet_01v8_lvt ad=0.147 pd=1.33 as=0.147 ps=1.33 w=1.05 l=0.15
X84 a_488_2016# IN OUT VSS sky130_fd_pr__nfet_01v8_lvt ad=0.147 pd=1.33 as=0.147 ps=1.33 w=1.05 l=0.15
X85 a_1520_840# IN OUT VSS sky130_fd_pr__nfet_01v8_lvt ad=0.147 pd=1.33 as=0.147 ps=1.33 w=1.05 l=0.15
X86 a_2036_4326# IN OUT VDD sky130_fd_pr__pfet_01v8_lvt ad=0.147 pd=1.33 as=0.147 ps=1.33 w=1.05 l=0.15
X87 a_2380_3150# IN a_2294_3150# VDD sky130_fd_pr__pfet_01v8_lvt ad=0.147 pd=1.33 as=0.147 ps=1.33 w=1.05 l=0.15
X88 OUT IN a_1348_840# VSS sky130_fd_pr__nfet_01v8_lvt ad=0.147 pd=1.33 as=0.147 ps=1.33 w=1.05 l=0.15
X89 a_230_2016# IN VSS VSS sky130_fd_pr__nfet_01v8_lvt ad=0.147 pd=1.33 as=0.27825 ps=2.63 w=1.05 l=0.15
X90 a_2122_3150# IN a_2036_3150# VDD sky130_fd_pr__pfet_01v8_lvt ad=0.147 pd=1.33 as=0.147 ps=1.33 w=1.05 l=0.15
X91 a_2638_4326# IN a_2552_4326# VDD sky130_fd_pr__pfet_01v8_lvt ad=0.147 pd=1.33 as=0.147 ps=1.33 w=1.05 l=0.15
X92 a_1864_840# IN a_1778_840# VSS sky130_fd_pr__nfet_01v8_lvt ad=0.147 pd=1.33 as=0.147 ps=1.33 w=1.05 l=0.15
X93 a_832_2016# IN a_746_2016# VSS sky130_fd_pr__nfet_01v8_lvt ad=0.147 pd=1.33 as=0.147 ps=1.33 w=1.05 l=0.15
X94 OUT IN a_1348_2016# VSS sky130_fd_pr__nfet_01v8_lvt ad=0.147 pd=1.33 as=0.147 ps=1.33 w=1.05 l=0.15
X95 VDD IN a_2638_3150# VDD sky130_fd_pr__pfet_01v8_lvt ad=0.27825 pd=2.63 as=0.147 ps=1.33 w=1.05 l=0.15
X96 OUT IN a_316_840# VSS sky130_fd_pr__nfet_01v8_lvt ad=0.147 pd=1.33 as=0.147 ps=1.33 w=1.05 l=0.15
X97 VSS IN a_1090_2016# VSS sky130_fd_pr__nfet_01v8_lvt ad=0.147 pd=1.33 as=0.147 ps=1.33 w=1.05 l=0.15
X98 a_574_2016# IN a_488_2016# VSS sky130_fd_pr__nfet_01v8_lvt ad=0.147 pd=1.33 as=0.147 ps=1.33 w=1.05 l=0.15
X99 a_2380_840# IN a_2294_840# VSS sky130_fd_pr__nfet_01v8_lvt ad=0.147 pd=1.33 as=0.147 ps=1.33 w=1.05 l=0.15
X100 a_316_2016# IN a_230_2016# VSS sky130_fd_pr__nfet_01v8_lvt ad=0.147 pd=1.33 as=0.147 ps=1.33 w=1.05 l=0.15
X101 a_1778_2016# IN VSS VSS sky130_fd_pr__nfet_01v8_lvt ad=0.147 pd=1.33 as=0.147 ps=1.33 w=1.05 l=0.15
X102 OUT IN a_832_2016# VSS sky130_fd_pr__nfet_01v8_lvt ad=0.147 pd=1.33 as=0.147 ps=1.33 w=1.05 l=0.15
X103 a_746_840# IN VSS VSS sky130_fd_pr__nfet_01v8_lvt ad=0.147 pd=1.33 as=0.147 ps=1.33 w=1.05 l=0.15
X104 OUT IN a_2380_4326# VDD sky130_fd_pr__pfet_01v8_lvt ad=0.147 pd=1.33 as=0.147 ps=1.33 w=1.05 l=0.15
X105 a_1262_2016# IN VSS VSS sky130_fd_pr__nfet_01v8_lvt ad=0.147 pd=1.33 as=0.147 ps=1.33 w=1.05 l=0.15
X106 VSS IN a_574_2016# VSS sky130_fd_pr__nfet_01v8_lvt ad=0.147 pd=1.33 as=0.147 ps=1.33 w=1.05 l=0.15
X107 VDD IN a_2122_4326# VDD sky130_fd_pr__pfet_01v8_lvt ad=0.147 pd=1.33 as=0.147 ps=1.33 w=1.05 l=0.15
X108 OUT IN a_316_2016# VSS sky130_fd_pr__nfet_01v8_lvt ad=0.147 pd=1.33 as=0.147 ps=1.33 w=1.05 l=0.15
X109 a_1864_2016# IN a_1778_2016# VSS sky130_fd_pr__nfet_01v8_lvt ad=0.147 pd=1.33 as=0.147 ps=1.33 w=1.05 l=0.15
X110 a_1004_2016# IN OUT VSS sky130_fd_pr__nfet_01v8_lvt ad=0.147 pd=1.33 as=0.147 ps=1.33 w=1.05 l=0.15
X111 a_1606_2016# IN a_1520_2016# VSS sky130_fd_pr__nfet_01v8_lvt ad=0.147 pd=1.33 as=0.147 ps=1.33 w=1.05 l=0.15
X112 a_2552_4326# IN OUT VDD sky130_fd_pr__pfet_01v8_lvt ad=0.147 pd=1.33 as=0.147 ps=1.33 w=1.05 l=0.15
X113 a_2294_4326# IN VDD VDD sky130_fd_pr__pfet_01v8_lvt ad=0.147 pd=1.33 as=0.147 ps=1.33 w=1.05 l=0.15
X114 VSS IN a_1090_840# VSS sky130_fd_pr__nfet_01v8_lvt ad=0.147 pd=1.33 as=0.147 ps=1.33 w=1.05 l=0.15
X115 a_1090_2016# IN a_1004_2016# VSS sky130_fd_pr__nfet_01v8_lvt ad=0.147 pd=1.33 as=0.147 ps=1.33 w=1.05 l=0.15
X116 a_1348_3150# IN a_1262_3150# VDD sky130_fd_pr__pfet_01v8_lvt ad=0.147 pd=1.33 as=0.147 ps=1.33 w=1.05 l=0.15
X117 a_746_3150# IN VDD VDD sky130_fd_pr__pfet_01v8_lvt ad=0.147 pd=1.33 as=0.147 ps=1.33 w=1.05 l=0.15
X118 OUT IN a_1864_2016# VSS sky130_fd_pr__nfet_01v8_lvt ad=0.147 pd=1.33 as=0.147 ps=1.33 w=1.05 l=0.15
X119 a_488_3150# IN OUT VDD sky130_fd_pr__pfet_01v8_lvt ad=0.147 pd=1.33 as=0.147 ps=1.33 w=1.05 l=0.15
.ends
