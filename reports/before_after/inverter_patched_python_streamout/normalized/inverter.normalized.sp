.subckt inverter vss vdd in out
mn0_nf0_stk0 out in mn0_nf0_s0 vss sky130_fd_pr__nfet_01v8_lvt w=1.05 L=0.15
mn0_nf0_stk1 mn0_nf0_s0 in mn0_nf0_s1 vss sky130_fd_pr__nfet_01v8_lvt w=1.05 L=0.15
mn0_nf0_stk2 mn0_nf0_s1 in vss vss sky130_fd_pr__nfet_01v8_lvt w=1.05 L=0.15
mn0_nf1_stk0 out in mn0_nf1_s0 vss sky130_fd_pr__nfet_01v8_lvt w=1.05 L=0.15
mn0_nf1_stk1 mn0_nf1_s0 in mn0_nf1_s1 vss sky130_fd_pr__nfet_01v8_lvt w=1.05 L=0.15
mn0_nf1_stk2 mn0_nf1_s1 in vss vss sky130_fd_pr__nfet_01v8_lvt w=1.05 L=0.15
mn0_nf2_stk0 out in mn0_nf2_s0 vss sky130_fd_pr__nfet_01v8_lvt w=1.05 L=0.15
mn0_nf2_stk1 mn0_nf2_s0 in mn0_nf2_s1 vss sky130_fd_pr__nfet_01v8_lvt w=1.05 L=0.15
mn0_nf2_stk2 mn0_nf2_s1 in vss vss sky130_fd_pr__nfet_01v8_lvt w=1.05 L=0.15
mn0_nf3_stk0 out in mn0_nf3_s0 vss sky130_fd_pr__nfet_01v8_lvt w=1.05 L=0.15
mn0_nf3_stk1 mn0_nf3_s0 in mn0_nf3_s1 vss sky130_fd_pr__nfet_01v8_lvt w=1.05 L=0.15
mn0_nf3_stk2 mn0_nf3_s1 in vss vss sky130_fd_pr__nfet_01v8_lvt w=1.05 L=0.15
mn0_nf4_stk0 out in mn0_nf4_s0 vss sky130_fd_pr__nfet_01v8_lvt w=1.05 L=0.15
mn0_nf4_stk1 mn0_nf4_s0 in mn0_nf4_s1 vss sky130_fd_pr__nfet_01v8_lvt w=1.05 L=0.15
mn0_nf4_stk2 mn0_nf4_s1 in vss vss sky130_fd_pr__nfet_01v8_lvt w=1.05 L=0.15
mn0_nf5_stk0 out in mn0_nf5_s0 vss sky130_fd_pr__nfet_01v8_lvt w=1.05 L=0.15
mn0_nf5_stk1 mn0_nf5_s0 in mn0_nf5_s1 vss sky130_fd_pr__nfet_01v8_lvt w=1.05 L=0.15
mn0_nf5_stk2 mn0_nf5_s1 in vss vss sky130_fd_pr__nfet_01v8_lvt w=1.05 L=0.15
mn0_nf6_stk0 out in mn0_nf6_s0 vss sky130_fd_pr__nfet_01v8_lvt w=1.05 L=0.15
mn0_nf6_stk1 mn0_nf6_s0 in mn0_nf6_s1 vss sky130_fd_pr__nfet_01v8_lvt w=1.05 L=0.15
mn0_nf6_stk2 mn0_nf6_s1 in vss vss sky130_fd_pr__nfet_01v8_lvt w=1.05 L=0.15
mn0_nf7_stk0 out in mn0_nf7_s0 vss sky130_fd_pr__nfet_01v8_lvt w=1.05 L=0.15
mn0_nf7_stk1 mn0_nf7_s0 in mn0_nf7_s1 vss sky130_fd_pr__nfet_01v8_lvt w=1.05 L=0.15
mn0_nf7_stk2 mn0_nf7_s1 in vss vss sky130_fd_pr__nfet_01v8_lvt w=1.05 L=0.15
mn0_nf8_stk0 out in mn0_nf8_s0 vss sky130_fd_pr__nfet_01v8_lvt w=1.05 L=0.15
mn0_nf8_stk1 mn0_nf8_s0 in mn0_nf8_s1 vss sky130_fd_pr__nfet_01v8_lvt w=1.05 L=0.15
mn0_nf8_stk2 mn0_nf8_s1 in vss vss sky130_fd_pr__nfet_01v8_lvt w=1.05 L=0.15
mn0_nf9_stk0 out in mn0_nf9_s0 vss sky130_fd_pr__nfet_01v8_lvt w=1.05 L=0.15
mn0_nf9_stk1 mn0_nf9_s0 in mn0_nf9_s1 vss sky130_fd_pr__nfet_01v8_lvt w=1.05 L=0.15
mn0_nf9_stk2 mn0_nf9_s1 in vss vss sky130_fd_pr__nfet_01v8_lvt w=1.05 L=0.15
mn0_nf10_stk0 out in mn0_nf10_s0 vss sky130_fd_pr__nfet_01v8_lvt w=1.05 L=0.15
mn0_nf10_stk1 mn0_nf10_s0 in mn0_nf10_s1 vss sky130_fd_pr__nfet_01v8_lvt w=1.05 L=0.15
mn0_nf10_stk2 mn0_nf10_s1 in vss vss sky130_fd_pr__nfet_01v8_lvt w=1.05 L=0.15
mn0_nf11_stk0 out in mn0_nf11_s0 vss sky130_fd_pr__nfet_01v8_lvt w=1.05 L=0.15
mn0_nf11_stk1 mn0_nf11_s0 in mn0_nf11_s1 vss sky130_fd_pr__nfet_01v8_lvt w=1.05 L=0.15
mn0_nf11_stk2 mn0_nf11_s1 in vss vss sky130_fd_pr__nfet_01v8_lvt w=1.05 L=0.15
mn0_nf12_stk0 out in mn0_nf12_s0 vss sky130_fd_pr__nfet_01v8_lvt w=1.05 L=0.15
mn0_nf12_stk1 mn0_nf12_s0 in mn0_nf12_s1 vss sky130_fd_pr__nfet_01v8_lvt w=1.05 L=0.15
mn0_nf12_stk2 mn0_nf12_s1 in vss vss sky130_fd_pr__nfet_01v8_lvt w=1.05 L=0.15
mn0_nf13_stk0 out in mn0_nf13_s0 vss sky130_fd_pr__nfet_01v8_lvt w=1.05 L=0.15
mn0_nf13_stk1 mn0_nf13_s0 in mn0_nf13_s1 vss sky130_fd_pr__nfet_01v8_lvt w=1.05 L=0.15
mn0_nf13_stk2 mn0_nf13_s1 in vss vss sky130_fd_pr__nfet_01v8_lvt w=1.05 L=0.15
mn0_nf14_stk0 out in mn0_nf14_s0 vss sky130_fd_pr__nfet_01v8_lvt w=1.05 L=0.15
mn0_nf14_stk1 mn0_nf14_s0 in mn0_nf14_s1 vss sky130_fd_pr__nfet_01v8_lvt w=1.05 L=0.15
mn0_nf14_stk2 mn0_nf14_s1 in vss vss sky130_fd_pr__nfet_01v8_lvt w=1.05 L=0.15
mn0_nf15_stk0 out in mn0_nf15_s0 vss sky130_fd_pr__nfet_01v8_lvt w=1.05 L=0.15
mn0_nf15_stk1 mn0_nf15_s0 in mn0_nf15_s1 vss sky130_fd_pr__nfet_01v8_lvt w=1.05 L=0.15
mn0_nf15_stk2 mn0_nf15_s1 in vss vss sky130_fd_pr__nfet_01v8_lvt w=1.05 L=0.15
mn0_nf16_stk0 out in mn0_nf16_s0 vss sky130_fd_pr__nfet_01v8_lvt w=1.05 L=0.15
mn0_nf16_stk1 mn0_nf16_s0 in mn0_nf16_s1 vss sky130_fd_pr__nfet_01v8_lvt w=1.05 L=0.15
mn0_nf16_stk2 mn0_nf16_s1 in vss vss sky130_fd_pr__nfet_01v8_lvt w=1.05 L=0.15
mn0_nf17_stk0 out in mn0_nf17_s0 vss sky130_fd_pr__nfet_01v8_lvt w=1.05 L=0.15
mn0_nf17_stk1 mn0_nf17_s0 in mn0_nf17_s1 vss sky130_fd_pr__nfet_01v8_lvt w=1.05 L=0.15
mn0_nf17_stk2 mn0_nf17_s1 in vss vss sky130_fd_pr__nfet_01v8_lvt w=1.05 L=0.15
mn0_nf18_stk0 out in mn0_nf18_s0 vss sky130_fd_pr__nfet_01v8_lvt w=1.05 L=0.15
mn0_nf18_stk1 mn0_nf18_s0 in mn0_nf18_s1 vss sky130_fd_pr__nfet_01v8_lvt w=1.05 L=0.15
mn0_nf18_stk2 mn0_nf18_s1 in vss vss sky130_fd_pr__nfet_01v8_lvt w=1.05 L=0.15
mn0_nf19_stk0 out in mn0_nf19_s0 vss sky130_fd_pr__nfet_01v8_lvt w=1.05 L=0.15
mn0_nf19_stk1 mn0_nf19_s0 in mn0_nf19_s1 vss sky130_fd_pr__nfet_01v8_lvt w=1.05 L=0.15
mn0_nf19_stk2 mn0_nf19_s1 in vss vss sky130_fd_pr__nfet_01v8_lvt w=1.05 L=0.15
mp0_nf0_stk0 out in mp0_nf0_s0 vdd sky130_fd_pr__pfet_01v8_lvt w=1.05 L=0.15
mp0_nf0_stk1 mp0_nf0_s0 in mp0_nf0_s1 vdd sky130_fd_pr__pfet_01v8_lvt w=1.05 L=0.15
mp0_nf0_stk2 mp0_nf0_s1 in vdd vdd sky130_fd_pr__pfet_01v8_lvt w=1.05 L=0.15
mp0_nf1_stk0 out in mp0_nf1_s0 vdd sky130_fd_pr__pfet_01v8_lvt w=1.05 L=0.15
mp0_nf1_stk1 mp0_nf1_s0 in mp0_nf1_s1 vdd sky130_fd_pr__pfet_01v8_lvt w=1.05 L=0.15
mp0_nf1_stk2 mp0_nf1_s1 in vdd vdd sky130_fd_pr__pfet_01v8_lvt w=1.05 L=0.15
mp0_nf2_stk0 out in mp0_nf2_s0 vdd sky130_fd_pr__pfet_01v8_lvt w=1.05 L=0.15
mp0_nf2_stk1 mp0_nf2_s0 in mp0_nf2_s1 vdd sky130_fd_pr__pfet_01v8_lvt w=1.05 L=0.15
mp0_nf2_stk2 mp0_nf2_s1 in vdd vdd sky130_fd_pr__pfet_01v8_lvt w=1.05 L=0.15
mp0_nf3_stk0 out in mp0_nf3_s0 vdd sky130_fd_pr__pfet_01v8_lvt w=1.05 L=0.15
mp0_nf3_stk1 mp0_nf3_s0 in mp0_nf3_s1 vdd sky130_fd_pr__pfet_01v8_lvt w=1.05 L=0.15
mp0_nf3_stk2 mp0_nf3_s1 in vdd vdd sky130_fd_pr__pfet_01v8_lvt w=1.05 L=0.15
mp0_nf4_stk0 out in mp0_nf4_s0 vdd sky130_fd_pr__pfet_01v8_lvt w=1.05 L=0.15
mp0_nf4_stk1 mp0_nf4_s0 in mp0_nf4_s1 vdd sky130_fd_pr__pfet_01v8_lvt w=1.05 L=0.15
mp0_nf4_stk2 mp0_nf4_s1 in vdd vdd sky130_fd_pr__pfet_01v8_lvt w=1.05 L=0.15
mp0_nf5_stk0 out in mp0_nf5_s0 vdd sky130_fd_pr__pfet_01v8_lvt w=1.05 L=0.15
mp0_nf5_stk1 mp0_nf5_s0 in mp0_nf5_s1 vdd sky130_fd_pr__pfet_01v8_lvt w=1.05 L=0.15
mp0_nf5_stk2 mp0_nf5_s1 in vdd vdd sky130_fd_pr__pfet_01v8_lvt w=1.05 L=0.15
mp0_nf6_stk0 out in mp0_nf6_s0 vdd sky130_fd_pr__pfet_01v8_lvt w=1.05 L=0.15
mp0_nf6_stk1 mp0_nf6_s0 in mp0_nf6_s1 vdd sky130_fd_pr__pfet_01v8_lvt w=1.05 L=0.15
mp0_nf6_stk2 mp0_nf6_s1 in vdd vdd sky130_fd_pr__pfet_01v8_lvt w=1.05 L=0.15
mp0_nf7_stk0 out in mp0_nf7_s0 vdd sky130_fd_pr__pfet_01v8_lvt w=1.05 L=0.15
mp0_nf7_stk1 mp0_nf7_s0 in mp0_nf7_s1 vdd sky130_fd_pr__pfet_01v8_lvt w=1.05 L=0.15
mp0_nf7_stk2 mp0_nf7_s1 in vdd vdd sky130_fd_pr__pfet_01v8_lvt w=1.05 L=0.15
mp0_nf8_stk0 out in mp0_nf8_s0 vdd sky130_fd_pr__pfet_01v8_lvt w=1.05 L=0.15
mp0_nf8_stk1 mp0_nf8_s0 in mp0_nf8_s1 vdd sky130_fd_pr__pfet_01v8_lvt w=1.05 L=0.15
mp0_nf8_stk2 mp0_nf8_s1 in vdd vdd sky130_fd_pr__pfet_01v8_lvt w=1.05 L=0.15
mp0_nf9_stk0 out in mp0_nf9_s0 vdd sky130_fd_pr__pfet_01v8_lvt w=1.05 L=0.15
mp0_nf9_stk1 mp0_nf9_s0 in mp0_nf9_s1 vdd sky130_fd_pr__pfet_01v8_lvt w=1.05 L=0.15
mp0_nf9_stk2 mp0_nf9_s1 in vdd vdd sky130_fd_pr__pfet_01v8_lvt w=1.05 L=0.15
mp0_nf10_stk0 out in mp0_nf10_s0 vdd sky130_fd_pr__pfet_01v8_lvt w=1.05 L=0.15
mp0_nf10_stk1 mp0_nf10_s0 in mp0_nf10_s1 vdd sky130_fd_pr__pfet_01v8_lvt w=1.05 L=0.15
mp0_nf10_stk2 mp0_nf10_s1 in vdd vdd sky130_fd_pr__pfet_01v8_lvt w=1.05 L=0.15
mp0_nf11_stk0 out in mp0_nf11_s0 vdd sky130_fd_pr__pfet_01v8_lvt w=1.05 L=0.15
mp0_nf11_stk1 mp0_nf11_s0 in mp0_nf11_s1 vdd sky130_fd_pr__pfet_01v8_lvt w=1.05 L=0.15
mp0_nf11_stk2 mp0_nf11_s1 in vdd vdd sky130_fd_pr__pfet_01v8_lvt w=1.05 L=0.15
mp0_nf12_stk0 out in mp0_nf12_s0 vdd sky130_fd_pr__pfet_01v8_lvt w=1.05 L=0.15
mp0_nf12_stk1 mp0_nf12_s0 in mp0_nf12_s1 vdd sky130_fd_pr__pfet_01v8_lvt w=1.05 L=0.15
mp0_nf12_stk2 mp0_nf12_s1 in vdd vdd sky130_fd_pr__pfet_01v8_lvt w=1.05 L=0.15
mp0_nf13_stk0 out in mp0_nf13_s0 vdd sky130_fd_pr__pfet_01v8_lvt w=1.05 L=0.15
mp0_nf13_stk1 mp0_nf13_s0 in mp0_nf13_s1 vdd sky130_fd_pr__pfet_01v8_lvt w=1.05 L=0.15
mp0_nf13_stk2 mp0_nf13_s1 in vdd vdd sky130_fd_pr__pfet_01v8_lvt w=1.05 L=0.15
mp0_nf14_stk0 out in mp0_nf14_s0 vdd sky130_fd_pr__pfet_01v8_lvt w=1.05 L=0.15
mp0_nf14_stk1 mp0_nf14_s0 in mp0_nf14_s1 vdd sky130_fd_pr__pfet_01v8_lvt w=1.05 L=0.15
mp0_nf14_stk2 mp0_nf14_s1 in vdd vdd sky130_fd_pr__pfet_01v8_lvt w=1.05 L=0.15
mp0_nf15_stk0 out in mp0_nf15_s0 vdd sky130_fd_pr__pfet_01v8_lvt w=1.05 L=0.15
mp0_nf15_stk1 mp0_nf15_s0 in mp0_nf15_s1 vdd sky130_fd_pr__pfet_01v8_lvt w=1.05 L=0.15
mp0_nf15_stk2 mp0_nf15_s1 in vdd vdd sky130_fd_pr__pfet_01v8_lvt w=1.05 L=0.15
mp0_nf16_stk0 out in mp0_nf16_s0 vdd sky130_fd_pr__pfet_01v8_lvt w=1.05 L=0.15
mp0_nf16_stk1 mp0_nf16_s0 in mp0_nf16_s1 vdd sky130_fd_pr__pfet_01v8_lvt w=1.05 L=0.15
mp0_nf16_stk2 mp0_nf16_s1 in vdd vdd sky130_fd_pr__pfet_01v8_lvt w=1.05 L=0.15
mp0_nf17_stk0 out in mp0_nf17_s0 vdd sky130_fd_pr__pfet_01v8_lvt w=1.05 L=0.15
mp0_nf17_stk1 mp0_nf17_s0 in mp0_nf17_s1 vdd sky130_fd_pr__pfet_01v8_lvt w=1.05 L=0.15
mp0_nf17_stk2 mp0_nf17_s1 in vdd vdd sky130_fd_pr__pfet_01v8_lvt w=1.05 L=0.15
mp0_nf18_stk0 out in mp0_nf18_s0 vdd sky130_fd_pr__pfet_01v8_lvt w=1.05 L=0.15
mp0_nf18_stk1 mp0_nf18_s0 in mp0_nf18_s1 vdd sky130_fd_pr__pfet_01v8_lvt w=1.05 L=0.15
mp0_nf18_stk2 mp0_nf18_s1 in vdd vdd sky130_fd_pr__pfet_01v8_lvt w=1.05 L=0.15
mp0_nf19_stk0 out in mp0_nf19_s0 vdd sky130_fd_pr__pfet_01v8_lvt w=1.05 L=0.15
mp0_nf19_stk1 mp0_nf19_s0 in mp0_nf19_s1 vdd sky130_fd_pr__pfet_01v8_lvt w=1.05 L=0.15
mp0_nf19_stk2 mp0_nf19_s1 in vdd vdd sky130_fd_pr__pfet_01v8_lvt w=1.05 L=0.15
.ends inverter
